* Extracted by KLayout with SG13G2 LVS runset on : 22/10/2026 13:14

.SUBCKT uart_core VSS VDD rx_busy prescale[7] rx_data[7] prescale[15]
+ rx_data[6] prescale[3] prescale[2] prescale[4] rx_data[5] prescale[1]
+ prescale[0] tx_data[1] rx_data[4] rst rx_data[0] txd tx_data[5] rx_valid
+ rx_data[2] rx_data[3] tx_ready rx_ready tx_busy tx_valid prescale[8]
+ prescale[11] prescale[14] tx_data[4] prescale[10] prescale[5] prescale[9]
+ tx_data[6] prescale[12] rx_data[1] tx_data[3] rxd rx_frame_error tx_data[7]
+ rx_overrun_error clk prescale[13] prescale[6] tx_data[2] tx_data[0]
X$10118 VSS \$188 \$220 \$174 \$219 VDD sg13g2_dfrbpq_1
X$10131 \$166 VDD VSS sg13g2_tiehi
X$10149 VDD VSS \$167 \$176 \$178 sg13g2_xnor2_1
X$10158 VDD VSS \$168 \$193 \$176 sg13g2_and2_1
X$10164 VDD VSS \$223 \$243 sg13g2_inv_1
X$10213 VSS \$185 VDD \$175 \$169 sg13g2_xor2_1
X$10218 \$179 VDD VSS sg13g2_tiehi
X$10654 \$217 VDD VSS sg13g2_tiehi
X$10660 VDD VSS \$276 \$259 \$236 \$218 sg13g2_nor3_1
X$10680 \$188 VDD VSS sg13g2_tiehi
X$10696 VDD VSS \$190 \$174 \$209 \$218 sg13g2_nor3_1
X$10697 VDD VSS \$190 \$189 \$220 sg13g2_xnor2_1
X$10712 VDD VSS \$220 \$222 sg13g2_inv_1
X$10719 VDD VSS \$167 \$191 \$211 \$177 sg13g2_nor3_1
X$10730 VDD VSS \$176 \$222 \$189 sg13g2_and2_1
X$10740 VDD \$222 VSS \$195 \$193 \$243 \$189 sg13g2_nand4_1
X$10744 VDD VSS \$178 \$193 sg13g2_inv_1
X$10760 VDD VSS \$223 \$168 \$252 sg13g2_nand2b_1
X$10763 \$225 VDD VSS sg13g2_tiehi
X$10782 \$226 VDD VSS sg13g2_tiehi
X$10784 VSS \$279 VDD \$263 \$254 \$177 \$175 \$194 sg13g2_a221oi_1
X$10793 VDD VSS \$194 \$228 \$195 sg13g2_nand2_1
X$10798 \$228 \$175 \$195 VDD VSS sg13g2_or2_1
X$10800 VDD VSS \$197 \$200 \$185 \$177 sg13g2_nor3_1
X$10813 VDD VSS \$169 \$228 \$201 \$195 \$202 sg13g2_nor4_1
X$10815 VSS \$179 \$169 \$200 \$281 VDD sg13g2_dfrbpq_1
X$11214 VSS \$330 \$290 \$300 \$260 VDD sg13g2_dfrbpq_1
X$11234 VSS \$217 \$277 \$259 \$260 VDD sg13g2_dfrbpq_1
X$11242 VDD VSS \$292 \$275 \$290 \$274 sg13g2_nor3_1
X$11246 VDD VSS \$290 \$274 \$292 \$277 \$189 sg13g2_nor4_1
X$11262 \$336 VDD VSS sg13g2_tiehi
X$11281 VSS \$166 \$178 \$191 \$219 VDD sg13g2_dfrbpq_1
X$11293 VSS \$254 VDD \$269 sg13g2_buf_1
X$11341 VSS \$293 VDD \$316 \$269 \$177 \$195 \$252 sg13g2_a221oi_1
X$11346 VSS \$225 \$223 \$316 \$295 VDD sg13g2_dfrbpq_1
X$11368 VSS \$226 \$228 \$263 \$295 VDD sg13g2_dfrbpq_1
X$11409 VDD VSS \$296 \$283 \$258 \$177 sg13g2_nor3_1
X$11416 VSS VDD \$258 \$202 \$325 sg13g2_nor2b_1
X$11426 VSS \$280 \$201 \$283 \$281 VDD sg13g2_dfrbpq_1
X$11432 \$280 VDD VSS sg13g2_tiehi
X$11814 VSS \$329 \$274 \$354 \$260 VDD sg13g2_dfrbpq_1
X$11815 \$329 VDD VSS sg13g2_tiehi
X$11820 \$330 VDD VSS sg13g2_tiehi
X$11828 VDD VSS \$289 \$300 \$317 \$218 sg13g2_nor3_1
X$11840 VSS \$289 VDD \$290 \$274 sg13g2_xor2_1
X$11861 VDD \$394 VSS \$334 \$396 \$218 sg13g2_a21oi_1
X$11863 VSS \$360 VDD \$292 \$290 \$274 sg13g2_o21ai_1
X$11872 VDD VSS \$276 \$275 \$277 sg13g2_xnor2_1
X$11877 VDD VSS \$360 \$275 \$486 sg13g2_nand2b_1
X$11908 VSS \$336 \$338 \$363 \$219 VDD sg13g2_dfrbpq_1
X$11916 VDD VSS \$365 \$218 \$363 sg13g2_nor2_1
X$11930 \$365 VSS VDD \$369 \$254 \$376 \$338 sg13g2_a22oi_1
X$11934 VSS VDD \$341 \$370 \$339 sg13g2_nor2b_1
X$11942 VDD VSS \$339 \$370 \$327 sg13g2_nand2b_1
X$11946 VDD VSS \$369 \$381 \$341 sg13g2_nand2_1
X$11954 VSS \$342 \$294 \$382 \$295 VDD sg13g2_dfrbpq_1
X$11955 \$342 VDD VSS sg13g2_tiehi
X$11962 VSS \$177 VDD \$343 sg13g2_buf_1
X$11974 VDD VSS \$327 \$320 \$384 \$294 sg13g2_nor3_1
X$11978 VSS VDD \$385 \$320 \$422 sg13g2_nor2b_1
X$11981 VDD VSS \$345 \$320 \$321 sg13g2_xnor2_1
X$11983 VDD VSS \$345 \$372 \$386 \$343 sg13g2_nor3_1
X$11990 VSS \$323 \$321 \$372 \$295 VDD sg13g2_dfrbpq_1
X$11993 \$440 VDD VSS sg13g2_tiehi
X$12028 VSS \$325 VDD \$201 \$175 \$169 sg13g2_o21ai_1
X$12035 VDD VSS \$401 \$346 \$202 sg13g2_nand2_1
X$12043 VDD VSS \$348 \$202 \$350 sg13g2_nand2b_1
X$12044 \$347 VDD VSS sg13g2_tiehi
X$12436 VDD VSS \$474 \$411 \$473 \$612 sg13g2_nor3_1
X$12445 VSS \$412 \$453 \$590 \$260 VDD sg13g2_dfrbpq_1
X$12457 VDD VSS \$218 \$274 \$455 \$317 \$354 sg13g2_nor4_1
X$12479 VSS \$414 \$292 \$394 \$260 VDD sg13g2_dfrbpq_1
X$12482 \$414 VDD VSS sg13g2_tiehi
X$12489 VSS \$334 VDD \$486 \$437 \$454 sg13g2_o21ai_1
X$12496 VSS \$552 \$456 VDD sg13g2_buf_8
X$12504 \$415 VDD VSS sg13g2_tiehi
X$12506 VDD VSS \$641 \$218 \$405 sg13g2_nor2_1
X$12513 VSS \$456 \$219 VDD sg13g2_buf_8
X$12527 VDD VSS \$417 \$339 \$496 \$416 sg13g2_nor3_1
X$12529 VDD VSS \$338 \$416 \$496 \$370 \$445 sg13g2_nor4_1
X$12530 VSS \$458 VDD \$339 \$370 sg13g2_xor2_1
X$12539 VDD VSS \$518 \$381 \$445 sg13g2_nand2_1
X$12568 VDD VSS \$406 \$341 \$294 sg13g2_xnor2_1
X$12573 VDD VSS \$406 \$382 \$420 \$177 sg13g2_nor3_1
X$12595 VDD VSS \$321 \$381 \$384 \$294 sg13g2_nor3_1
X$12596 VSS \$422 VDD \$384 \$327 \$294 sg13g2_o21ai_1
X$12615 VDD VSS \$385 \$423 \$407 \$177 sg13g2_nor3_1
X$12635 VSS \$440 \$384 \$423 \$796 VDD sg13g2_dfrbpq_1
X$12640 \$323 VDD VSS sg13g2_tiehi
X$12647 VSS \$503 \$295 VDD sg13g2_buf_8
X$12656 VSS \$500 VDD \$493 \$254 \$177 \$401 \$350 sg13g2_a221oi_1
X$12667 VDD VSS \$557 \$424 \$401 sg13g2_nand2_1
X$12669 VDD VSS \$417 \$346 \$202 \$424 sg13g2_nand3b_1
X$12671 \$432 VDD VSS sg13g2_tiehi
X$12679 VSS \$432 \$424 \$488 \$281 VDD sg13g2_dfrbpq_1
X$12686 VDD VSS \$348 \$346 sg13g2_inv_1
X$12708 VSS \$768 \$281 VDD sg13g2_buf_8
X$12710 VSS \$426 VDD \$388 \$387 \$430 \$542 \$410 sg13g2_a221oi_1
X$13055 VSS \$474 VDD \$508 \$472 sg13g2_xor2_1
X$13061 VSS \$509 VDD \$452 \$508 \$472 sg13g2_o21ai_1
X$13078 \$412 VDD VSS sg13g2_tiehi
X$13083 VDD VSS \$452 \$454 \$317 sg13g2_nor2_1
X$13098 VDD VSS \$590 \$511 \$453 \$521 sg13g2_a21o_1
X$13129 VSS \$343 VDD \$513 sg13g2_buf_1
X$13130 VSS \$218 VDD \$343 sg13g2_buf_1
X$13139 VDD VSS \$396 \$576 \$455 sg13g2_nand2_1
X$13148 VSS \$578 VDD \$236 \$582 \$521 \$576 \$437 sg13g2_a221oi_1
X$13155 \$517 VDD VSS sg13g2_tiehi
X$13159 VSS \$415 \$370 \$405 \$219 VDD sg13g2_dfrbpq_1
X$13177 VDD VSS \$417 \$416 \$669 sg13g2_nor2_1
X$13179 VDD VSS \$577 \$416 \$417 sg13g2_and2_1
X$13187 VDD VSS \$518 \$417 \$269 sg13g2_nor2_1
X$13195 \$641 VSS VDD \$461 \$646 \$458 \$455 sg13g2_a22oi_1
X$13198 \$417 \$520 \$518 VDD VSS sg13g2_or2_1
X$13210 VSS \$578 VDD \$209 \$437 \$521 \$463 \$524 sg13g2_a221oi_1
X$13224 VSS \$525 VDD \$437 sg13g2_buf_1
X$13231 VSS \$461 VDD \$420 \$525 \$526 \$463 \$462 sg13g2_a221oi_1
X$13233 VSS \$526 VDD \$520 sg13g2_buf_1
X$13249 \$293 VSS VDD \$622 \$525 \$621 \$463 sg13g2_a22oi_1
X$13263 VSS \$462 VDD \$407 \$530 \$526 \$582 \$535 sg13g2_a221oi_1
X$13264 VSS \$532 VDD \$386 \$531 \$526 \$530 \$535 sg13g2_a221oi_1
X$13280 \$279 VSS VDD \$741 \$525 \$622 \$463 sg13g2_a22oi_1
X$13286 \$464 VSS VDD \$437 \$582 \$617 \$537 sg13g2_a22oi_1
X$13287 \$500 VSS VDD \$537 \$539 \$525 \$463 sg13g2_a22oi_1
X$13308 VSS \$557 VDD \$488 \$417 \$343 \$269 \$464 sg13g2_a221oi_1
X$13337 VSS \$347 \$348 \$493 \$295 VDD sg13g2_dfrbpq_1
X$13363 VDD VSS \$540 \$465 \$542 \$541 sg13g2_or3_1
X$13368 VSS \$682 \$465 \$585 \$683 VDD sg13g2_dfrbpq_1
X$13381 VDD VSS \$465 \$844 sg13g2_inv_1
X$13385 VSS \$466 \$543 \$388 \$281 VDD sg13g2_dfrbpq_1
X$13404 VSS \$684 \$799 \$770 \$281 VDD sg13g2_dfrbpq_1
X$13609 \$688 VDD VSS sg13g2_tiehi
X$13610 VDD VSS \$690 \$650 \$649 sg13g2_nor2_1
X$13621 VDD \$690 VSS \$454 \$472 \$411 sg13g2_a21oi_1
X$13630 VDD VSS \$612 \$611 \$732 sg13g2_and2_1
X$13642 VDD VSS \$612 \$650 \$473 \$657 \$511 sg13g2_nor4_1
X$13655 VDD VSS \$473 \$454 \$611 \$582 sg13g2_a21o_1
X$13658 VDD VSS \$521 \$660 \$513 sg13g2_nor2_1
X$13663 VDD VSS \$612 \$582 \$530 sg13g2_nor2_1
X$13670 VSS \$454 VDD \$520 sg13g2_buf_1
X$13678 VDD VSS \$254 \$650 \$521 sg13g2_nor2_1
X$13686 VSS \$517 \$416 \$707 \$219 VDD sg13g2_dfrbpq_1
X$13712 VSS \$669 VDD \$713 \$518 \$577 \$617 \$667 sg13g2_a221oi_1
X$13741 VSS \$463 VDD \$582 sg13g2_buf_1
X$13753 VSS \$524 VDD \$211 \$525 \$521 \$463 \$621 sg13g2_a221oi_1
X$13775 VDD VSS \$376 \$808 \$525 \$532 sg13g2_a21o_1
X$13799 VDD VSS \$674 \$622 sg13g2_inv_1
X$13837 VSS \$677 \$503 VDD sg13g2_buf_8
X$13870 VDD \$585 VSS \$541 \$681 \$430 sg13g2_a21oi_1
X$13877 \$682 VDD VSS sg13g2_tiehi
X$13886 VDD VSS \$542 \$769 \$843 sg13g2_nand2_1
X$13895 \$466 VDD VSS sg13g2_tiehi
X$13909 VSS \$1001 \$916 \$771 \$683 VDD sg13g2_dfrbpq_1
X$14042 VSS \$688 \$472 \$649 \$816 VDD sg13g2_dfrbpq_1
X$14061 VDD VSS \$509 \$473 \$758 sg13g2_nand2b_1
X$14065 VDD VSS \$452 \$611 \$732 sg13g2_nand2_1
X$14073 VDD VSS \$657 \$733 \$453 sg13g2_xnor2_1
X$14084 VSS VDD \$531 \$453 \$733 sg13g2_nor2b_1
X$14089 VSS \$582 VDD \$531 sg13g2_buf_1
X$14094 VSS \$456 \$260 VDD sg13g2_buf_8
X$14105 VDD VSS \$667 \$254 \$437 sg13g2_and2_1
X$14125 VDD \$707 VSS \$713 \$813 \$343 sg13g2_a21oi_1
X$14126 VDD VSS \$760 \$669 \$496 sg13g2_xnor2_1
X$14159 VDD VSS \$809 \$763 sg13g2_inv_1
X$14164 VDD VSS \$738 \$621 sg13g2_inv_1
X$14177 VDD VSS \$535 \$831 \$764 sg13g2_xnor2_1
X$14181 VSS \$426 VDD \$905 \$462 \$765 sg13g2_o21ai_1
X$14191 VSS \$741 VDD \$197 \$525 \$454 \$463 \$744 sg13g2_a221oi_1
X$14200 VDD \$841 VSS \$801 \$750 \$430 sg13g2_a21oi_1
X$14201 \$797 VDD VSS sg13g2_tiehi
X$14202 VSS \$767 \$677 VDD sg13g2_buf_8
X$14205 VSS \$750 VDD \$798 \$542 \$465 sg13g2_o21ai_1
X$14209 VDD VSS \$681 \$465 \$542 sg13g2_nand2_1
X$14214 VSS \$677 \$768 VDD sg13g2_buf_8
X$14223 VDD VSS \$543 \$769 sg13g2_inv_1
X$14237 \$684 VDD VSS sg13g2_tiehi
X$14381 \$815 VDD VSS sg13g2_tiehi
X$14383 VDD VSS \$853 \$650 \$892 sg13g2_nor2_1
X$14402 VDD VSS \$508 \$733 \$788 \$472 sg13g2_nor3_1
X$14409 VDD VSS \$788 \$472 \$789 sg13g2_nor2_1
X$14428 VSS VDD \$732 \$789 \$453 sg13g2_nor2b_1
X$14438 VDD VSS \$733 \$453 \$820 sg13g2_nand2b_1
X$14460 VDD VSS \$865 \$660 sg13g2_inv_1
X$14468 VDD \$870 VSS \$582 \$611 \$650 sg13g2_a21oi_1
X$14491 VSS \$437 VDD \$530 sg13g2_buf_1
X$14500 \$824 VDD VSS sg13g2_tiehi
X$14512 VDD VSS \$760 \$873 \$812 \$218 sg13g2_nor3_1
X$14521 VDD VSS \$813 \$455 \$825 sg13g2_nand2_1
X$14532 VSS \$825 VDD \$812 \$437 \$526 \$582 \$827 sg13g2_a221oi_1
X$14550 VSS \$871 \$835 \$461 \$809 VDD sg13g2_mux2_1
X$14563 VDD VSS \$793 \$764 \$820 \$831 \$808 sg13g2_nor4_1
X$14569 VSS \$532 VDD \$794 \$793 sg13g2_xor2_1
X$14583 VSS \$1077 \$835 \$532 \$793 VDD sg13g2_mux2_1
X$14596 VDD VSS \$833 \$798 \$764 \$765 sg13g2_a21o_1
X$14611 VDD VSS \$801 \$387 \$879 sg13g2_nand2_1
X$14636 VSS \$797 \$798 \$841 \$796 VDD sg13g2_dfrbpq_1
X$14673 VDD VSS \$798 \$995 sg13g2_inv_1
X$14682 VSS \$387 VDD \$860 sg13g2_buf_1
X$14685 VDD VSS \$543 \$843 \$410 sg13g2_nand2b_1
X$14703 VDD \$770 VSS \$800 \$846 \$858 sg13g2_a21oi_1
X$14712 VDD VSS \$847 \$799 \$800 sg13g2_nand2b_1
X$14859 VSS \$815 \$788 \$892 \$816 VDD sg13g2_dfrbpq_1
X$14868 VDD VSS \$732 \$967 \$454 \$865 sg13g2_nor3_1
X$14880 VDD VSS \$929 \$508 \$789 sg13g2_nand2_1
X$14883 VDD VSS \$929 \$453 \$821 sg13g2_nor2_1
X$14889 VDD VSS \$870 \$821 \$865 sg13g2_nand2b_1
X$14896 VSS \$1214 \$552 VDD sg13g2_buf_8
X$14900 VDD VSS \$454 \$820 \$455 sg13g2_nor2_1
X$14904 VSS \$824 \$496 \$873 \$796 VDD sg13g2_dfrbpq_1
X$14916 VDD VSS \$646 \$526 \$437 \$827 sg13g2_a21o_1
X$14926 VDD VSS \$827 \$765 \$943 sg13g2_nor2_1
X$14933 VDD VSS \$825 \$901 \$902 sg13g2_xnor2_1
X$14938 VDD VSS \$949 \$902 \$765 sg13g2_nand2_1
X$14947 VDD VSS \$904 \$794 \$764 \$903 sg13g2_nor3_1
X$14953 VDD VSS \$765 \$903 \$905 sg13g2_nand2b_1
X$14962 VDD \$540 VSS \$535 \$835 \$833 sg13g2_a21oi_1
X$14969 VSS \$744 VDD \$296 \$525 \$454 \$463 \$539 sg13g2_a221oi_1
X$14974 VDD VSS \$950 \$430 \$840 sg13g2_nor2_1
X$14977 VSS \$946 \$909 \$840 \$796 VDD sg13g2_dfrbpq_1
X$14985 VDD VSS \$910 \$843 \$937 sg13g2_nand2b_1
X$14994 VDD \$995 VSS \$847 \$769 \$844 \$843 sg13g2_nand4_1
X$15016 VDD \$771 VSS \$922 \$846 \$430 sg13g2_a21oi_1
X$15031 VSS \$915 VDD \$847 sg13g2_buf_1
X$15168 VDD VSS \$963 \$962 \$964 \$611 sg13g2_nand3_1
X$15174 \$853 VSS VDD \$667 \$788 \$758 \$733 sg13g2_a22oi_1
X$15180 VSS \$1126 \$508 \$1013 \$816 VDD sg13g2_dfrbpq_1
X$15203 VSS \$971 rx_busy \$1086 \$816 VDD sg13g2_dfrbpq_1
X$15241 VDD VSS \$827 \$977 \$900 sg13g2_xnor2_1
X$15248 VDD \$907 VSS \$765 \$900 \$943 sg13g2_a21oi_1
X$15254 VDD \$763 VSS \$904 \$902 \$900 \$901 sg13g2_nand4_1
X$15267 VDD VSS \$462 \$904 \$903 sg13g2_xnor2_1
X$15274 VSS \$503 \$796 VDD sg13g2_buf_8
X$15294 VSS \$950 VDD \$1038 \$907 \$974 sg13g2_o21ai_1
X$15302 VSS \$430 VDD \$858 sg13g2_buf_1
X$15307 VDD VSS \$985 \$430 \$986 sg13g2_nor2_1
X$15314 \$987 VDD VSS sg13g2_tiehi
X$15327 VDD VSS \$1038 \$990 \$909 sg13g2_xnor2_1
X$15330 VDD VSS \$909 \$991 \$1025 \$992 \$843 sg13g2_nor4_1
X$15342 VSS \$768 \$683 VDD sg13g2_buf_8
X$15354 VDD VSS \$846 \$1030 \$387 sg13g2_nand2_1
X$15362 \$1001 VDD VSS sg13g2_tiehi
X$15369 VSS \$922 VDD \$915 \$920 \$914 sg13g2_o21ai_1
X$15372 VDD VSS \$920 \$799 \$916 sg13g2_and2_1
X$15497 VSS \$960 \$1121 \$1059 \$816 VDD sg13g2_dfrbpq_1
X$15502 \$961 VDD VSS sg13g2_tiehi
X$15506 VDD VSS \$1051 \$1050 sg13g2_inv_1
X$15513 VSS \$962 VDD \$820 sg13g2_buf_1
X$15526 VSS \$1066 \$816 VDD sg13g2_buf_8
X$15546 VDD \$1013 VSS \$254 \$508 \$1116 sg13g2_a21oi_1
X$15563 VSS \$1066 \$1344 VDD sg13g2_buf_8
X$15571 \$971 VDD VSS sg13g2_tiehi
X$15578 VSS \$1169 VDD \$1053 \$455 rx_busy sg13g2_o21ai_1
X$15595 \$1087 VDD VSS sg13g2_tiehi
X$15599 VDD VSS \$974 \$976 \$975 \$1054 sg13g2_or3_1
X$15623 VDD VSS \$1183 \$900 \$977 sg13g2_nand2_1
X$15634 VSS \$835 VDD \$1030 sg13g2_buf_1
X$15644 VSS \$1135 clk VDD sg13g2_buf_16
X$15692 VDD VSS \$879 \$1077 sg13g2_dlygate4sd3_1
X$15709 VSS \$858 VDD \$1220 sg13g2_buf_1
X$15718 VSS \$985 VDD \$937 \$871 \$974 sg13g2_o21ai_1
X$15730 VSS \$987 \$1025 \$986 \$683 VDD sg13g2_dfrbpq_1
X$15752 \$991 \$990 \$992 VDD VSS sg13g2_or2_1
X$15764 VDD VSS \$1097 \$991 \$992 sg13g2_nand2_1
X$15769 VSS \$1069 \$991 \$1108 \$683 VDD sg13g2_dfrbpq_1
X$15790 VDD \$1098 VSS \$846 \$1064 \$430 sg13g2_a21oi_1
X$15813 VSS VDD \$1063 \$914 \$1005 sg13g2_nor2b_1
X$15823 VDD VSS \$916 \$799 \$914 sg13g2_nor2_1
X$15958 VSS \$1059 VDD \$1120 \$964 \$1148 sg13g2_o21ai_1
X$15961 VDD VSS \$1120 \$962 \$964 \$1051 sg13g2_nand3_1
X$15967 VSS \$1124 VDD \$963 \$964 \$1050 sg13g2_o21ai_1
X$15971 VSS \$964 VDD \$967 sg13g2_buf_1
X$15977 VDD VSS \$650 \$1296 sg13g2_inv_1
X$15982 VSS \$1115 VDD \$1053 \$1254 \$1051 sg13g2_o21ai_1
X$15984 VSS \$1116 VDD \$1053 \$667 \$508 sg13g2_o21ai_1
X$15989 \$1362 VDD VSS sg13g2_tiehi
X$15994 VDD VSS \$1258 \$821 \$254 \$611 sg13g2_nand3_1
X$15996 VDD VSS \$1162 \$821 \$254 sg13g2_nand2_1
X$15999 VDD \$1086 VSS \$455 \$611 \$1169 sg13g2_a21oi_1
X$16012 VSS \$1087 \$1264 \$1172 \$796 VDD sg13g2_dfrbpq_1
X$16019 VDD VSS \$461 \$1183 \$809 sg13g2_xnor2_1
X$16021 VSS \$1030 VDD \$1134 sg13g2_buf_1
X$16023 VSS \$1096 VDD \$949 \$825 \$765 sg13g2_o21ai_1
X$16027 \$903 \$831 \$904 VDD VSS sg13g2_or2_1
X$16030 VDD VSS \$1092 \$901 \$617 sg13g2_nand2b_1
X$16034 VSS \$1111 \$835 \$539 \$1138 VDD sg13g2_mux2_1
X$16035 VDD \$1181 VSS \$1111 \$1140 \$1095 sg13g2_a21oi_1
X$16041 \$946 VDD VSS sg13g2_tiehi
X$16050 \$1142 VDD VSS sg13g2_tiehi
X$16060 VSS \$1096 VDD \$1108 \$387 \$430 \$990 \$1097 sg13g2_a221oi_1
X$16069 \$1069 VDD VSS sg13g2_tiehi
X$16082 \$1171 VDD VSS sg13g2_tiehi
X$16091 VSS \$1064 VDD \$915 \$1063 \$1099 sg13g2_o21ai_1
X$16093 VDD VSS \$1005 \$1099 \$916 \$799 sg13g2_nor3_1
X$16217 \$960 VDD VSS sg13g2_tiehi
X$16232 VDD VSS \$1121 \$1148 sg13g2_inv_1
X$16240 VDD VSS \$1123 \$962 \$964 \$1121 sg13g2_nand3_1
X$16242 VSS \$961 \$1051 \$1124 \$816 VDD sg13g2_dfrbpq_1
X$16260 \$1126 VDD VSS sg13g2_tiehi
X$16265 VSS \$1053 VDD \$1213 sg13g2_buf_1
X$16282 VSS \$552 \$1066 VDD sg13g2_buf_8
X$16313 \$1310 VDD VSS sg13g2_tiehi
X$16323 VSS \$1135 \$1214 VDD sg13g2_buf_8
X$16330 VDD \$1172 VSS \$1179 \$1054 \$1131 sg13g2_a21oi_1
X$16335 VSS \$1179 VDD \$1264 \$974 \$1177 sg13g2_o21ai_1
X$16366 VDD VSS \$1241 \$900 sg13g2_inv_1
X$16377 VSS \$765 VDD \$1136 sg13g2_buf_1
X$16394 VDD VSS \$1137 \$1138 \$1215 \$1271 \$901 sg13g2_nor4_1
X$16399 VSS \$1092 VDD \$1137 \$1216 \$1215 sg13g2_o21ai_1
X$16409 VDD VSS \$387 \$1131 \$1095 sg13g2_nor2_1
X$16415 VDD VSS \$1363 \$1209 sg13g2_inv_1
X$16421 VSS \$1219 VDD \$1140 \$1136 \$537 sg13g2_o21ai_1
X$16434 VSS \$974 VDD \$915 sg13g2_buf_1
X$16440 VSS \$1135 \$767 VDD sg13g2_buf_8
X$16453 VSS \$910 VDD \$1025 \$990 \$909 sg13g2_o21ai_1
X$16468 VDD VSS \$1282 \$1143 \$1144 sg13g2_nor2_1
X$16471 VSS VDD \$860 \$843 \$844 \$769 \$995 sg13g2_and4_1
X$16488 \$1352 VDD VSS sg13g2_tiehi
X$16515 VDD VSS \$916 \$1286 \$799 \$1005 \$1287 sg13g2_or4_1
X$16637 VSS \$1245 \$1247 \$1244 \$1342 VDD sg13g2_dfrbpq_1
X$16645 VSS \$1250 VDD \$1123 \$964 \$1249 sg13g2_o21ai_1
X$16656 VSS \$1297 VDD \$1053 \$1254 \$1121 sg13g2_o21ai_1
X$16663 VDD \$1253 VSS \$1254 \$1252 \$1297 sg13g2_a21oi_1
X$16668 VSS \$1213 VDD \$1296 sg13g2_buf_1
X$16673 VDD \$1343 VSS \$1254 \$1302 \$1115 sg13g2_a21oi_1
X$16674 VSS \$1254 VDD \$1258 sg13g2_buf_1
X$16681 VDD VSS rx_data[7] \$1302 sg13g2_inv_1
X$16687 VSS \$1310 \$1177 \$1308 \$1259 VDD sg13g2_dfrbpq_1
X$16693 VDD \$1312 VSS \$974 \$1177 \$1313 sg13g2_a21oi_1
X$16695 VDD VSS \$974 \$1313 \$1263 \$1177 sg13g2_nor3_1
X$16704 VDD VSS \$1321 \$1177 \$976 sg13g2_nand2_1
X$16712 \$1264 \$1134 \$1321 VDD VSS sg13g2_or2_1
X$16718 VDD VSS \$1217 \$1266 \$576 sg13g2_xnor2_1
X$16725 VDD VSS \$1536 \$902 sg13g2_inv_1
X$16742 prescale[7] \$1216 \$1271 VDD VSS sg13g2_or2_1
X$16747 VDD VSS \$537 \$1216 \$1215 sg13g2_xnor2_1
X$16753 VDD VSS \$1095 \$1140 \$1220 sg13g2_nor2_1
X$16759 VDD VSS \$1219 \$1334 sg13g2_inv_1
X$16771 VSS \$1327 VDD \$1334 \$835 \$1215 sg13g2_o21ai_1
X$16774 VDD VSS \$1277 \$1213 \$915 sg13g2_nand2_1
X$16781 \$1350 VSS VDD \$1280 \$1277 \$1356 \$992 sg13g2_a22oi_1
X$16800 VDD VSS \$1281 \$1282 \$1143 \$1279 \$992 sg13g2_or4_1
X$16806 VDD VSS \$1181 \$1390 \$1283 sg13g2_nor2_1
X$16823 VSS \$1225 VDD \$1383 \$1287 \$1220 \$387 \$1217 sg13g2_a221oi_1
X$16832 VDD VSS \$1286 \$1099 \$1225 sg13g2_nand2b_1
X$16962 VSS \$1341 \$1413 \$1354 \$1342 VDD sg13g2_dfrbpq_1
X$16971 \$1518 VDD VSS sg13g2_tiehi
X$16977 VSS \$1359 \$1342 VDD sg13g2_buf_8
X$16992 \$1372 VDD VSS sg13g2_tiehi
X$17009 VSS \$1362 rx_data[7] \$1343 \$1344 VDD sg13g2_dfrbpq_1
X$17035 VDD VSS \$1312 \$650 \$1308 sg13g2_nor2_1
X$17047 VSS \$1405 VDD \$1053 \$1346 \$1375 sg13g2_o21ai_1
X$17064 VDD VSS \$975 \$1347 \$1263 \$1315 \$1346 sg13g2_nor4_1
X$17088 VDD VSS \$1321 \$1264 \$1325 sg13g2_nor2_1
X$17101 VDD VSS \$1378 \$576 sg13g2_inv_1
X$17108 VSS \$1266 VDD \$1136 sg13g2_buf_1
X$17115 VSS \$1136 VDD \$1325 sg13g2_buf_1
X$17150 VDD VSS \$539 \$1271 \$1138 sg13g2_xnor2_1
X$17167 VSS \$1363 VDD \$1140 \$617 \$765 sg13g2_o21ai_1
X$17182 VSS \$1356 VDD \$1209 \$835 \$1137 sg13g2_o21ai_1
X$17202 VDD \$1431 VSS \$1327 \$1277 \$1455 sg13g2_a21oi_1
X$17205 \$1351 VDD VSS sg13g2_tiehi
X$17216 VSS \$767 \$1626 VDD sg13g2_buf_8
X$17224 VDD VSS \$1279 \$1355 \$1280 sg13g2_nand2b_1
X$17246 \$1432 VDD VSS sg13g2_tiehi
X$17266 VSS \$1171 \$1005 \$1098 \$1384 VDD sg13g2_dfrbpq_1
X$17398 \$1341 VDD VSS sg13g2_tiehi
X$17410 VSS \$1354 VDD \$1445 \$1411 \$1392 sg13g2_o21ai_1
X$17413 VDD VSS \$1413 \$1392 sg13g2_inv_1
X$17415 VDD VSS \$1415 \$1249 sg13g2_inv_1
X$17426 \$1417 VDD VSS sg13g2_tiehi
X$17435 VSS \$1372 rx_data[6] \$1253 \$1344 VDD sg13g2_dfrbpq_1
X$17443 VDD VSS \$1344 \$I42690 sg13g2_inv_1
X$17445 VSS \$1465 \$1375 \$1466 \$1344 VDD sg13g2_dfrbpq_1
X$17460 VDD VSS \$1347 \$1375 \$976 sg13g2_nor2_1
X$17466 \$1177 \$975 \$1264 VDD VSS sg13g2_or2_1
X$17475 VDD VSS \$578 \$1377 \$1378 sg13g2_xnor2_1
X$17480 VDD VSS \$977 \$902 \$901 sg13g2_and2_1
X$17485 VDD VSS \$738 \$1423 \$1478 sg13g2_xnor2_1
X$17489 VDD VSS \$1136 \$1378 \$1426 sg13g2_nor2_1
X$17497 VDD VSS \$793 prescale[15] sg13g2_dlygate4sd3_1
X$17502 VDD VSS \$744 \$1429 \$1504 sg13g2_xnor2_1
X$17523 VDD VSS \$1449 \$1459 sg13g2_dlygate4sd3_1
X$17529 VSS \$1142 \$1279 \$1350 \$683 VDD sg13g2_dfrbpq_1
X$17539 VDD VSS \$1282 \$1355 \$1281 \$1143 sg13g2_nor3_1
X$17542 VSS \$1390 VDD \$1282 \$1143 sg13g2_xor2_1
X$17548 \$1636 VDD VSS sg13g2_tiehi
X$17553 VSS \$1352 \$1286 \$1383 \$1384 VDD sg13g2_dfrbpq_1
X$17689 VSS \$1411 VDD \$964 sg13g2_buf_1
X$17697 VDD VSS \$1445 \$962 \$964 \$1415 sg13g2_nand3_1
X$17714 VSS \$1518 \$1415 \$1250 \$1342 VDD sg13g2_dfrbpq_1
X$17723 VSS \$1523 VDD \$1053 \$1254 \$1415 sg13g2_o21ai_1
X$17732 VDD VSS rx_data[6] \$1252 sg13g2_inv_1
X$17739 VDD \$1582 VSS \$1254 \$1525 \$1523 sg13g2_a21oi_1
X$17751 VDD VSS rx_data[5] \$1525 sg13g2_inv_1
X$17761 \$1465 VDD VSS sg13g2_tiehi
X$17767 VSS \$1214 \$1736 VDD sg13g2_buf_8
X$17777 VSS VDD \$1466 \$1405 \$1492 sg13g2_nor2b_1
X$17784 VDD VSS \$1492 \$1375 \$1346 sg13g2_nand2_1
X$17795 VSS \$1671 VDD \$1347 \$974 \$975 sg13g2_o21ai_1
X$17805 VDD VSS \$1675 rst sg13g2_dlygate4sd3_1
X$17822 VDD VSS \$1263 \$1131 \$1140 sg13g2_nor2_1
X$17846 VDD VSS \$1717 \$1423 \$524 sg13g2_nand2b_1
X$17862 VDD VSS prescale[3] prescale[2] prescale[0] prescale[1] \$1427
+ sg13g2_nor4_1
X$17874 VDD VSS \$674 \$1427 \$1498 sg13g2_xnor2_1
X$17888 VDD VSS prescale[4] \$1500 sg13g2_inv_1
X$17890 VDD VSS \$1428 \$1500 \$1427 sg13g2_and2_1
X$17902 VDD VSS \$1429 \$1503 \$1428 sg13g2_and2_1
X$17914 VDD VSS \$1464 \$1140 \$860 \$1030 sg13g2_nand3_1
X$17931 VDD \$1722 VSS \$835 \$741 \$915 sg13g2_a21oi_1
X$17944 VSS \$1351 \$1281 \$1431 \$1259 VDD sg13g2_dfrbpq_1
X$17958 VDD VSS \$1455 \$1144 \$1281 sg13g2_xnor2_1
X$17977 VSS \$1432 \$1143 \$1283 \$1384 VDD sg13g2_dfrbpq_1
X$17999 VDD VSS \$1437 \$858 \$1438 sg13g2_nor2_1
X$18006 \$1439 VDD VSS sg13g2_tiehi
X$18138 \$1245 VDD VSS sg13g2_tiehi
X$18146 VSS \$1244 VDD \$1606 \$1411 \$1643 sg13g2_o21ai_1
X$18150 VDD VSS \$1606 \$962 \$1411 \$1413 sg13g2_nand3_1
X$18162 VSS \$1578 VDD \$1053 \$1254 \$1413 sg13g2_o21ai_1
X$18164 VDD \$1609 VSS \$1254 \$1656 \$1578 sg13g2_a21oi_1
X$18169 VDD VSS rx_data[4] \$1656 sg13g2_inv_1
X$18180 \$1555 VDD VSS sg13g2_tiehi
X$18183 VSS \$1555 rx_data[5] \$1582 \$1344 VDD sg13g2_dfrbpq_1
X$18194 VSS \$1612 \$1347 \$1611 \$1589 VDD sg13g2_dfrbpq_1
X$18216 VSS \$1533 VDD \$1559 \$1266 \$1558 sg13g2_o21ai_1
X$18220 VSS \$1567 \$1030 \$524 \$1560 VDD sg13g2_mux2_1
X$18226 VDD VSS \$1266 \$738 \$1544 sg13g2_nor2_1
X$18234 VDD \$1459 VSS \$1266 \$1478 \$1544 sg13g2_a21oi_1
X$18239 VDD VSS \$1266 \$674 \$1618 sg13g2_nor2_1
X$18248 VDD \$1504 VSS \$1271 \$1500 \$1503 \$1427 sg13g2_nand4_1
X$18257 VDD VSS \$1619 \$1504 sg13g2_inv_1
X$18262 VDD VSS \$1620 tx_data[1] sg13g2_dlygate4sd3_1
X$18269 VDD \$1621 VSS \$835 \$744 \$974 sg13g2_a21oi_1
X$18275 VSS \$1795 \$1596 \$1879 \$1259 VDD sg13g2_dfrbpq_1
X$18282 VDD VSS \$1624 \$1593 \$1627 sg13g2_nand2_1
X$18286 VDD VSS \$1593 \$1631 \$1630 \$1596 \$1282 sg13g2_or4_1
X$18289 VDD VSS \$1507 \$1630 \$1631 sg13g2_nand2_1
X$18295 VSS \$1449 VDD \$1635 \$387 \$858 \$1631 \$1519 sg13g2_a221oi_1
X$18302 VSS \$1587 \$1384 VDD sg13g2_buf_8
X$18305 VSS \$1437 VDD \$1514 \$1567 \$915 sg13g2_o21ai_1
X$18309 VDD VSS \$1647 \$1571 \$1519 sg13g2_nand2b_1
X$18313 VDD VSS \$1574 \$1571 \$1514 sg13g2_nand2b_1
X$18316 VSS \$1574 VDD \$1702 \$1287 \$1572 sg13g2_o21ai_1
X$18447 VDD VSS \$1247 \$1643 sg13g2_inv_1
X$18466 VSS \$1417 rx_data[4] \$1609 \$1342 VDD sg13g2_dfrbpq_1
X$18493 VSS \$1610 rx_data[0] \$1690 \$1344 VDD sg13g2_dfrbpq_1
X$18500 \$1612 VDD VSS sg13g2_tiehi
X$18502 VDD \$1611 VSS \$1492 \$1671 \$1131 sg13g2_a21oi_1
X$18515 VDD VSS \$975 \$1843 \$1347 \$1375 sg13g2_nor3_1
X$18520 VSS \$1785 txd \$1712 \$1259 VDD sg13g2_dfrbpq_1
X$18531 VDD VSS \$1377 \$1423 \$1378 prescale[2] sg13g2_nor3_1
X$18540 VDD VSS \$1693 tx_data[5] sg13g2_dlygate4sd3_1
X$18551 VSS \$1622 \$1259 VDD sg13g2_buf_8
X$18566 VDD VSS \$1791 \$1503 sg13g2_inv_1
X$18567 VDD VSS \$1696 \$1220 \$1695 sg13g2_nor2_1
X$18571 VDD VSS \$1699 \$1619 \$1266 sg13g2_nand2_1
X$18577 VSS \$1626 \$1622 VDD sg13g2_buf_8
X$18586 VSS \$1719 VDD \$1743 \$1722 \$858 \$1625 \$1624 sg13g2_a221oi_1
X$18593 VDD VSS \$1716 \$1596 \$1625 sg13g2_nand2_1
X$18603 \$1593 \$1625 \$1627 VDD VSS sg13g2_or2_1
X$18611 VSS \$1626 \$1587 VDD sg13g2_buf_8
X$18634 VSS \$1636 \$1647 \$1635 \$1384 VDD sg13g2_dfrbpq_1
X$18654 VDD VSS \$1702 \$1287 \$1572 \$1647 \$1631 sg13g2_or4_1
X$18796 VDD VSS \$1732 \$1768 sg13g2_inv_1
X$18798 VDD VSS \$1805 \$962 \$1411 \$1247 sg13g2_nand3_1
X$18821 VDD VSS \$1865 \$962 \$1411 \$1734 sg13g2_nand3_1
X$18825 \$1813 VDD VSS sg13g2_tiehi
X$18830 VSS \$1825 VDD \$1053 \$1772 \$1247 sg13g2_o21ai_1
X$18831 VDD VSS \$1774 \$1820 sg13g2_inv_1
X$18837 VSS \$1736 \$1359 VDD sg13g2_buf_8
X$18847 VDD \$1907 VSS \$1772 \$1824 \$1825 sg13g2_a21oi_1
X$18850 \$1868 VDD VSS sg13g2_tiehi
X$18857 VSS \$1736 \$1835 VDD sg13g2_buf_8
X$18871 VSS \$1835 \$1589 VDD sg13g2_buf_8
X$18881 \$1785 VDD VSS sg13g2_tiehi
X$18892 VDD VSS \$1712 \$1787 \$1533 \$1213 sg13g2_nand3_1
X$18899 VDD VSS \$1315 \$1782 \$1559 sg13g2_nor2_1
X$18905 VSS \$1315 VDD \$915 sg13g2_buf_1
X$18908 VSS \$1717 VDD \$1560 prescale[1] prescale[0] sg13g2_o21ai_1
X$18923 VDD VSS \$1378 prescale[0] sg13g2_dlygate4sd3_1
X$18932 VSS \$1751 VDD \$1426 \$1377 sg13g2_xor2_1
X$18943 VDD \$1826 VSS \$1266 \$1498 \$1618 sg13g2_a21oi_1
X$18950 VDD VSS \$741 \$1428 \$1503 sg13g2_xnor2_1
X$18960 VDD VSS \$1719 \$1791 \$1266 sg13g2_nand2_1
X$18973 VDD VSS \$2175 \$1878 \$1829 sg13g2_nand2_1
X$18985 \$1795 VDD VSS sg13g2_tiehi
X$19002 VSS \$1796 \$1593 \$1743 \$1799 VDD sg13g2_dfrbpq_1
X$19026 VSS \$1744 \$1630 \$1880 \$1384 VDD sg13g2_dfrbpq_1
X$19037 VDD VSS \$1745 \$858 \$1800 sg13g2_nor2_1
X$19039 VDD VSS \$1881 \$1287 \$1572 sg13g2_xnor2_1
X$19052 VDD VSS \$1287 \$1571 \$1702 \$1572 sg13g2_nor3_1
X$19177 \$1858 VDD VSS sg13g2_tiehi
X$19187 VSS \$1886 VDD \$1805 \$1411 \$1768 sg13g2_o21ai_1
X$19196 VSS \$1892 VDD \$1859 \$1411 \$1895 sg13g2_o21ai_1
X$19208 VSS \$1863 VDD \$1213 \$1772 \$1732 sg13g2_o21ai_1
X$19214 VSS \$1903 VDD \$1865 \$967 \$1820 sg13g2_o21ai_1
X$19221 VSS \$1813 \$1774 \$1903 \$1939 VDD sg13g2_dfrbpq_1
X$19241 VSS \$1772 VDD \$1258 sg13g2_buf_1
X$19247 VDD VSS \$1911 \$1778 rx_valid sg13g2_nand2_1
X$19248 VDD VSS rx_data[3] \$1824 sg13g2_inv_1
X$19259 \$2074 VDD VSS sg13g2_tiehi
X$19264 VDD VSS \$1841 \$1920 \$1315 \$1131 sg13g2_nor3_1
X$19270 VSS VDD \$1263 \$1924 \$1782 sg13g2_nor2b_1
X$19272 VSS \$1782 VDD \$1792 sg13g2_buf_1
X$19277 VDD VSS \$1951 rx_ready sg13g2_dlygate4sd3_1
X$19278 VSS \$1787 VDD txd \$1315 \$1263 sg13g2_o21ai_1
X$19284 VDD VSS \$1873 \$1558 \$1872 sg13g2_nand2_1
X$19288 \$2002 VDD VSS sg13g2_tiehi
X$19299 VSS \$1935 \$2085 \$2157 \$1953 VDD sg13g2_dfrbpq_1
X$19318 VDD VSS \$903 prescale[13] sg13g2_dlygate4sd3_1
X$19325 VSS \$1925 VDD \$1792 sg13g2_buf_1
X$19336 VSS \$1829 VDD \$1464 sg13g2_buf_1
X$19340 VSS \$1699 VDD \$1879 \$1621 \$858 \$1282 \$1716 sg13g2_a221oi_1
X$19343 VDD VSS \$1904 \$1826 sg13g2_dlygate4sd3_1
X$19349 \$1796 VDD VSS sg13g2_tiehi
X$19362 VSS \$1904 VDD \$1880 \$387 \$858 \$1627 \$1507 sg13g2_a221oi_1
X$19364 \$1630 \$1627 \$1631 VDD VSS sg13g2_or2_1
X$19373 VSS \$1587 \$1799 VDD sg13g2_buf_8
X$19382 VSS \$1745 VDD \$1881 \$1751 \$915 sg13g2_o21ai_1
X$19387 VSS \$1439 \$1702 \$1438 \$1799 VDD sg13g2_dfrbpq_1
X$19507 VSS \$1858 \$1732 \$1886 \$2061 VDD sg13g2_dfrbpq_1
X$19525 VDD VSS \$1859 \$962 \$1411 \$1732 sg13g2_nand3_1
X$19535 VDD VSS \$1734 \$1895 sg13g2_inv_1
X$19547 VSS \$2067 VDD \$1213 \$1772 \$1734 sg13g2_o21ai_1
X$19554 VSS \$1359 \$2061 VDD sg13g2_buf_8
X$19569 VSS \$1940 VDD \$1213 \$1772 \$1774 sg13g2_o21ai_1
X$19577 \$1610 VDD VSS sg13g2_tiehi
X$19585 VSS \$1868 rx_data[3] \$1907 \$1939 VDD sg13g2_dfrbpq_1
X$19609 VSS \$1131 VDD \$1675 sg13g2_buf_1
X$19624 VSS \$1841 VDD \$2077 \$1782 tx_ready sg13g2_o21ai_1
X$19634 VSS \$1792 VDD \$1843 sg13g2_buf_1
X$19642 VDD VSS \$1924 tx_valid sg13g2_dlygate4sd3_1
X$19645 VDD VSS \$764 prescale[14] sg13g2_dlygate4sd3_1
X$19666 VSS \$2002 \$1558 \$1874 \$1259 VDD sg13g2_dfrbpq_1
X$19681 \$2022 VDD VSS sg13g2_tiehi
X$19682 VDD VSS \$1138 prescale[7] sg13g2_dlygate4sd3_1
X$19695 VDD \$1696 VSS \$860 \$1925 tx_busy sg13g2_a21oi_1
X$19708 VSS VDD \$1988 \$1925 \$1878 sg13g2_nor2b_1
X$19710 \$2001 VDD VSS sg13g2_tiehi
X$19725 VSS \$2110 \$1959 \$2176 \$1953 VDD sg13g2_dfrbpq_1
X$19751 \$1744 VDD VSS sg13g2_tiehi
X$19777 VSS \$1965 \$1572 \$1800 \$1799 VDD sg13g2_dfrbpq_1
X$19921 VSS \$2064 \$1734 \$1892 \$1342 VDD sg13g2_dfrbpq_1
X$19941 VSS \$2068 rx_data[2] \$2100 \$1939 VDD sg13g2_dfrbpq_1
X$19955 VDD \$1690 VSS \$1772 \$1977 \$1940 sg13g2_a21oi_1
X$19963 VDD VSS rx_data[0] \$1977 sg13g2_inv_1
X$19965 VDD VSS \$1162 \$1982 \$650 \$611 sg13g2_nor3_1
X$19985 VSS \$2076 \$2052 \$2113 \$1589 VDD sg13g2_dfrbpq_1
X$20002 VDD \$2027 VSS \$1782 \$2007 \$1988 sg13g2_a21oi_1
X$20009 VDD VSS \$1241 prescale[11] sg13g2_dlygate4sd3_1
X$20015 VDD VSS \$1791 prescale[5] sg13g2_dlygate4sd3_1
X$20018 VSS \$2022 tx_busy \$1695 \$1953 VDD sg13g2_dfrbpq_1
X$20027 VDD \$2087 VSS \$1925 \$1620 \$1986 sg13g2_a21oi_1
X$20032 VSS \$2001 \$1878 \$1956 \$1953 VDD sg13g2_dfrbpq_1
X$20047 VSS VDD \$1986 \$1792 \$1961 sg13g2_nor2b_1
X$20051 VDD VSS \$2095 \$1961 \$1829 sg13g2_nand2_1
X$20053 VSS \$2091 \$1961 \$2096 \$1799 VDD sg13g2_dfrbpq_1
X$20062 \$1965 VDD VSS sg13g2_tiehi
X$20204 \$2064 VDD VSS sg13g2_tiehi
X$20209 VSS \$2066 \$1778 \$2065 \$2061 VDD sg13g2_dfrbpq_1
X$20213 \$2068 VDD VSS sg13g2_tiehi
X$20220 VDD VSS rx_data[2] \$2240 sg13g2_inv_1
X$20224 VSS \$2187 rx_valid \$2105 \$1939 VDD sg13g2_dfrbpq_1
X$20248 VSS \$650 VDD \$1131 sg13g2_buf_1
X$20264 \$2222 VDD VSS sg13g2_tiehi
X$20274 \$2076 VDD VSS sg13g2_tiehi
X$20278 VDD VSS \$2077 \$1924 \$1782 tx_ready sg13g2_nand3_1
X$20281 VSS \$2113 \$1872 \$2052 \$1782 VDD sg13g2_mux2_1
X$20289 \$2138 VDD VSS sg13g2_tiehi
X$20294 VSS \$1874 VDD \$1873 \$2027 \$1872 sg13g2_o21ai_1
X$20310 VDD VSS \$809 prescale[12] sg13g2_dlygate4sd3_1
X$20318 VDD VSS \$1536 prescale[10] sg13g2_dlygate4sd3_1
X$20323 VDD VSS \$1137 prescale[9] sg13g2_dlygate4sd3_1
X$20331 VDD VSS \$2121 tx_data[4] sg13g2_dlygate4sd3_1
X$20336 VDD VSS \$2326 tx_data[6] sg13g2_dlygate4sd3_1
X$20340 VDD VSS \$1215 prescale[8] sg13g2_dlygate4sd3_1
X$20359 VSS \$1622 \$1953 VDD sg13g2_buf_8
X$20388 VSS \$2096 VDD \$2095 \$2089 \$1464 sg13g2_o21ai_1
X$20403 \$2091 VDD VSS sg13g2_tiehi
X$20556 \$2219 VDD VSS sg13g2_tiehi
X$20561 \$2062 VDD VSS sg13g2_tiehi
X$20565 \$2136 \$2268 \$2063 VDD VSS sg13g2_or2_1
X$20571 \$2066 VDD VSS sg13g2_tiehi
X$20587 VDD \$2161 VSS \$1258 \$2163 \$2067 sg13g2_a21oi_1
X$20611 VDD \$2105 VSS \$2149 \$1772 \$2136 sg13g2_a21oi_1
X$20617 VDD VSS rx_valid \$1951 \$2149 sg13g2_nand2b_1
X$20623 VDD VSS \$1911 \$2164 \$1162 \$2136 sg13g2_nor3_1
X$20632 \$2245 VDD VSS sg13g2_tiehi
X$20636 VSS \$2074 tx_ready \$1920 \$1939 VDD sg13g2_dfrbpq_1
X$20646 VSS VDD \$2166 \$1782 \$2052 sg13g2_nor2b_1
X$20649 VSS \$2138 \$2082 \$2167 \$1589 VDD sg13g2_dfrbpq_1
X$20667 \$1935 VDD VSS sg13g2_tiehi
X$20668 VSS \$2157 VDD \$2132 \$2172 \$1872 sg13g2_o21ai_1
X$20674 VDD VSS \$2132 \$2085 \$1872 sg13g2_nand2_1
X$20677 VSS VDD \$2252 \$2140 \$2085 sg13g2_nor2b_1
X$20682 VSS \$1872 VDD \$1464 sg13g2_buf_1
X$20688 \$2347 VDD VSS sg13g2_tiehi
X$20694 VDD VSS \$2200 \$2353 \$1829 sg13g2_nand2_1
X$20699 VSS \$1956 VDD \$2175 \$2087 \$1829 sg13g2_o21ai_1
X$20707 \$2110 VDD VSS sg13g2_tiehi
X$20711 VDD VSS \$2177 \$1959 \$1829 sg13g2_nand2_1
X$20715 VSS VDD \$2178 \$1925 \$1959 sg13g2_nor2b_1
X$20719 VDD \$2089 VSS \$1792 \$2179 \$2230 sg13g2_a21oi_1
X$20874 VSS \$2219 \$2063 \$2272 \$2061 VDD sg13g2_dfrbpq_1
X$20891 \$2136 \$2065 \$2267 VDD VSS sg13g2_or2_1
X$20895 \$2136 \$2272 \$2282 VDD VSS sg13g2_or2_1
X$20910 \$2239 VDD VSS sg13g2_tiehi
X$20913 VDD \$2100 VSS \$1772 \$2240 \$1863 sg13g2_a21oi_1
X$20927 VDD VSS rx_data[1] \$2163 sg13g2_inv_1
X$20939 \$2187 VDD VSS sg13g2_tiehi
X$20947 VSS \$1835 \$1939 VDD sg13g2_buf_8
X$20965 VSS \$2136 VDD \$1131 sg13g2_buf_1
X$20976 VSS \$611 VDD \$1778 sg13g2_buf_1
X$20980 VSS \$2222 rx_overrun_error \$2164 \$1589 VDD sg13g2_dfrbpq_1
X$20997 VDD \$2295 VSS \$1782 \$2246 \$2166 sg13g2_a21oi_1
X$21005 VSS \$2167 VDD \$2300 \$2295 \$1872 sg13g2_o21ai_1
X$21025 VDD VSS \$2300 \$2082 \$1872 sg13g2_nand2_1
X$21041 VDD VSS \$1560 prescale[2] sg13g2_dlygate4sd3_1
X$21052 VSS \$2140 VDD \$1792 sg13g2_buf_1
X$21061 VDD \$2172 VSS \$2140 \$2326 \$2226 sg13g2_a21oi_1
X$21077 VDD VSS \$1478 prescale[3] sg13g2_dlygate4sd3_1
X$21101 VSS \$2254 VDD \$2200 \$2341 \$1872 sg13g2_o21ai_1
X$21114 VDD VSS \$1619 prescale[6] sg13g2_dlygate4sd3_1
X$21127 VSS VDD \$2257 \$1925 \$2353 sg13g2_nor2b_1
X$21135 VDD \$2361 VSS \$1925 \$2121 \$2257 sg13g2_a21oi_1
X$21143 VSS \$2176 VDD \$2177 \$2361 \$1829 sg13g2_o21ai_1
X$21149 VDD VSS \$2179 tx_data[2] sg13g2_dlygate4sd3_1
X$21170 VDD \$2348 VSS \$1925 \$2229 \$2178 sg13g2_a21oi_1
X$21178 VSS \$2258 VDD \$2180 \$2348 \$1829 sg13g2_o21ai_1
X$21191 VDD VSS \$2180 \$2259 \$1829 sg13g2_nand2_1
X$21197 VSS \$2260 \$2259 \$2258 \$1799 VDD sg13g2_dfrbpq_1
X$21344 VSS \$2062 \$2267 \$2268 \$2061 VDD sg13g2_dfrbpq_1
X$21361 VSS \$2239 rx_data[1] \$2161 \$2061 VDD sg13g2_dfrbpq_1
X$21374 VDD VSS \$2282 rxd sg13g2_dlygate4sd3_1
X$21381 VSS \$2245 rx_frame_error \$1982 \$1589 VDD sg13g2_dfrbpq_1
X$21387 VDD VSS \$2246 tx_data[7] sg13g2_dlygate4sd3_1
X$21390 VDD VSS \$2007 tx_data[0] sg13g2_dlygate4sd3_1
X$21393 VDD VSS \$1377 prescale[1] sg13g2_dlygate4sd3_1
X$21408 VSS VDD \$2226 \$2140 \$2082 sg13g2_nor2b_1
X$21425 VDD VSS \$1498 prescale[4] sg13g2_dlygate4sd3_1
X$21431 VDD \$2341 VSS \$2140 \$1693 \$2252 sg13g2_a21oi_1
X$21436 VSS \$2347 \$2353 \$2254 \$1953 VDD sg13g2_dfrbpq_1
X$21446 VDD VSS \$2229 tx_data[3] sg13g2_dlygate4sd3_1
X$21463 VSS VDD \$2230 \$1925 \$2259 sg13g2_nor2b_1
X$21471 \$2260 VDD VSS sg13g2_tiehi
.ENDS uart_core

.SUBCKT sg13g2_nand3b_1 VDD VSS Y B C A_N
M$1 VSS A_N \$6 VSS sg13_lv_nmos L=0.13u W=0.55u AS=0.18575p AD=0.187p PS=1.26u
+ PD=1.78u rfmode=0
M$2 VSS C \$9 VSS sg13_lv_nmos L=0.13u W=0.74u AS=0.18575p AD=0.1406p PS=1.26u
+ PD=1.12u rfmode=0
M$3 \$9 B \$8 VSS sg13_lv_nmos L=0.13u W=0.74u AS=0.1406p AD=0.1406p PS=1.12u
+ PD=1.12u rfmode=0
M$4 \$8 \$6 Y VSS sg13_lv_nmos L=0.13u W=0.74u AS=0.1406p AD=0.3404p PS=1.12u
+ PD=2.4u rfmode=0
M$5 \$6 A_N VDD VDD sg13_lv_pmos L=0.13u W=0.84u AS=0.2856p AD=0.2198p PS=2.36u
+ PD=1.53u rfmode=0
M$6 VDD C Y VDD sg13_lv_pmos L=0.13u W=1.12u AS=0.2198p AD=0.2128p PS=1.53u
+ PD=1.5u rfmode=0
M$7 Y B VDD VDD sg13_lv_pmos L=0.13u W=1.12u AS=0.2128p AD=0.2128p PS=1.5u
+ PD=1.5u rfmode=0
M$8 VDD \$6 Y VDD sg13_lv_pmos L=0.13u W=1.12u AS=0.2128p AD=0.3808p PS=1.5u
+ PD=2.92u rfmode=0
.ENDS sg13g2_nand3b_1

.SUBCKT sg13g2_buf_16 VSS X A VDD
M$1 VSS \$3 X VSS sg13_lv_nmos L=0.13u W=11.84u AS=2.3606p AD=2.2496p PS=18.96u
+ PD=17.92u rfmode=0
M$17 VSS A \$3 VSS sg13_lv_nmos L=0.13u W=4.44u AS=0.8436p AD=0.9546p PS=6.72u
+ PD=7.76u rfmode=0
M$23 VDD \$3 X VDD sg13_lv_pmos L=0.13u W=17.92u AS=3.5896p AD=3.4048p
+ PS=25.45u PD=24u rfmode=0
M$39 VDD A \$3 VDD sg13_lv_pmos L=0.13u W=6.72u AS=1.2768p AD=1.4448p PS=9u
+ PD=10.42u rfmode=0
.ENDS sg13g2_buf_16

.SUBCKT sg13g2_a21o_1 VDD VSS X B1 A1 A2
M$1 X \$6 VSS VSS sg13_lv_nmos L=0.13u W=0.74u AS=0.2351p AD=0.15745p PS=2.16u
+ PD=1.175u rfmode=0
M$2 VSS B1 \$6 VSS sg13_lv_nmos L=0.13u W=0.64u AS=0.15745p AD=0.1216p
+ PS=1.175u PD=1.02u rfmode=0
M$3 \$6 A1 \$9 VSS sg13_lv_nmos L=0.13u W=0.64u AS=0.1216p AD=0.0816p PS=1.02u
+ PD=0.895u rfmode=0
M$4 \$9 A2 VSS VSS sg13_lv_nmos L=0.13u W=0.64u AS=0.0816p AD=0.2176p PS=0.895u
+ PD=1.96u rfmode=0
M$5 \$6 B1 \$5 VDD sg13_lv_pmos L=0.13u W=1u AS=0.35p AD=0.2125p PS=2.7u
+ PD=1.425u rfmode=0
M$6 \$5 A1 VDD VDD sg13_lv_pmos L=0.13u W=1u AS=0.2125p AD=0.19p PS=1.425u
+ PD=1.38u rfmode=0
M$7 VDD A2 \$5 VDD sg13_lv_pmos L=0.13u W=1u AS=0.19p AD=0.34p PS=1.38u
+ PD=2.68u rfmode=0
M$8 X \$6 VDD VDD sg13_lv_pmos L=0.13u W=1.12u AS=0.3808p AD=0.3808p PS=2.92u
+ PD=2.92u rfmode=0
.ENDS sg13g2_a21o_1

.SUBCKT sg13g2_or3_1 VDD VSS C A B X
M$1 \$6 C VSS VSS sg13_lv_nmos L=0.13u W=0.55u AS=0.187p AD=0.1045p PS=1.78u
+ PD=0.93u rfmode=0
M$2 VSS B \$6 VSS sg13_lv_nmos L=0.13u W=0.55u AS=0.1045p AD=0.198p PS=0.93u
+ PD=1.27u rfmode=0
M$3 \$6 A VSS VSS sg13_lv_nmos L=0.13u W=0.55u AS=0.198p AD=0.13395p PS=1.27u
+ PD=1.12u rfmode=0
M$4 VSS \$6 X VSS sg13_lv_nmos L=0.13u W=0.74u AS=0.13395p AD=0.2516p PS=1.12u
+ PD=2.16u rfmode=0
M$5 \$6 C \$9 VDD sg13_lv_pmos L=0.13u W=1u AS=0.34p AD=0.19p PS=2.68u PD=1.38u
+ rfmode=0
M$6 \$9 B \$8 VDD sg13_lv_pmos L=0.13u W=1u AS=0.19p AD=0.1575p PS=1.38u
+ PD=1.315u rfmode=0
M$7 \$8 A VDD VDD sg13_lv_pmos L=0.13u W=1u AS=0.1575p AD=0.3822p PS=1.315u
+ PD=1.84u rfmode=0
M$8 VDD \$6 X VDD sg13_lv_pmos L=0.13u W=1.12u AS=0.3822p AD=0.3808p PS=1.84u
+ PD=2.92u rfmode=0
.ENDS sg13g2_or3_1

.SUBCKT sg13g2_a22oi_1 Y VSS VDD A2 B2 B1 A1
M$1 VSS B1 \$10 VSS sg13_lv_nmos L=0.13u W=0.74u AS=0.2553p AD=0.13875p
+ PS=2.17u PD=1.115u rfmode=0
M$2 \$10 B2 Y VSS sg13_lv_nmos L=0.13u W=0.74u AS=0.13875p AD=0.2664p PS=1.115u
+ PD=1.46u rfmode=0
M$3 Y A1 \$9 VSS sg13_lv_nmos L=0.13u W=0.74u AS=0.2664p AD=0.0962p PS=1.46u
+ PD=1u rfmode=0
M$4 \$9 A2 VSS VSS sg13_lv_nmos L=0.13u W=0.74u AS=0.0962p AD=0.2516p PS=1u
+ PD=2.16u rfmode=0
M$5 VDD A1 \$5 VDD sg13_lv_pmos L=0.13u W=1.12u AS=0.3808p AD=0.2716p PS=2.92u
+ PD=1.605u rfmode=0
M$6 \$5 B1 Y VDD sg13_lv_pmos L=0.13u W=1.12u AS=0.2716p AD=0.2128p PS=1.605u
+ PD=1.5u rfmode=0
M$7 Y B2 \$5 VDD sg13_lv_pmos L=0.13u W=1.12u AS=0.2128p AD=0.2744p PS=1.5u
+ PD=1.61u rfmode=0
M$8 \$5 A2 VDD VDD sg13_lv_pmos L=0.13u W=1.12u AS=0.2744p AD=0.3808p PS=1.61u
+ PD=2.92u rfmode=0
.ENDS sg13g2_a22oi_1

.SUBCKT sg13g2_or2_1 A X B VDD VSS
M$1 VSS B \$6 VSS sg13_lv_nmos L=0.13u W=0.55u AS=0.187p AD=0.1045p PS=1.78u
+ PD=0.93u rfmode=0
M$2 \$6 A VSS VSS sg13_lv_nmos L=0.13u W=0.55u AS=0.1045p AD=0.1469p PS=0.93u
+ PD=1.155u rfmode=0
M$3 VSS \$6 X VSS sg13_lv_nmos L=0.13u W=0.74u AS=0.1469p AD=0.2516p PS=1.155u
+ PD=2.16u rfmode=0
M$4 \$6 B \$7 VDD sg13_lv_pmos L=0.13u W=0.84u AS=0.2856p AD=0.1596p PS=2.36u
+ PD=1.22u rfmode=0
M$5 VDD A \$7 VDD sg13_lv_pmos L=0.13u W=0.84u AS=0.2226p AD=0.1596p PS=1.535u
+ PD=1.22u rfmode=0
M$6 VDD \$6 X VDD sg13_lv_pmos L=0.13u W=1.12u AS=0.2226p AD=0.3976p PS=1.535u
+ PD=2.95u rfmode=0
.ENDS sg13g2_or2_1

.SUBCKT sg13g2_xor2_1 VSS X VDD B A
M$1 VSS A \$1 VSS sg13_lv_nmos L=0.13u W=0.55u AS=0.374p AD=0.174625p PS=2.46u
+ PD=1.185u rfmode=0
M$2 VSS B \$1 VSS sg13_lv_nmos L=0.13u W=0.55u AS=0.15245p AD=0.174625p
+ PS=1.17u PD=1.185u rfmode=0
M$3 VSS A \$8 VSS sg13_lv_nmos L=0.13u W=0.74u AS=0.15245p AD=0.0888p PS=1.17u
+ PD=0.98u rfmode=0
M$4 \$8 B X VSS sg13_lv_nmos L=0.13u W=0.74u AS=0.0888p AD=0.1628p PS=0.98u
+ PD=1.18u rfmode=0
M$5 X \$1 VSS VSS sg13_lv_nmos L=0.13u W=0.74u AS=0.1628p AD=0.3108p PS=1.18u
+ PD=2.32u rfmode=0
M$6 \$3 A VDD VDD sg13_lv_pmos L=0.13u W=1.12u AS=0.3808p AD=0.2128p PS=2.92u
+ PD=1.5u rfmode=0
M$7 VDD B \$3 VDD sg13_lv_pmos L=0.13u W=1.12u AS=0.2128p AD=0.2128p PS=1.5u
+ PD=1.5u rfmode=0
M$8 \$3 \$1 X VDD sg13_lv_pmos L=0.13u W=1.12u AS=0.2128p AD=0.3808p PS=1.5u
+ PD=2.92u rfmode=0
M$9 VDD A \$9 VDD sg13_lv_pmos L=0.13u W=1u AS=0.36p AD=0.1225p PS=2.72u
+ PD=1.245u rfmode=0
M$10 \$9 B \$1 VDD sg13_lv_pmos L=0.13u W=1u AS=0.1225p AD=0.34p PS=1.245u
+ PD=2.68u rfmode=0
.ENDS sg13g2_xor2_1

.SUBCKT sg13g2_nand3_1 VDD VSS Y B C A
M$1 VSS C \$8 VSS sg13_lv_nmos L=0.13u W=0.74u AS=0.2886p AD=0.1406p PS=2.26u
+ PD=1.12u rfmode=0
M$2 \$8 B \$7 VSS sg13_lv_nmos L=0.13u W=0.74u AS=0.1406p AD=0.1406p PS=1.12u
+ PD=1.12u rfmode=0
M$3 \$7 A Y VSS sg13_lv_nmos L=0.13u W=0.74u AS=0.1406p AD=0.2516p PS=1.12u
+ PD=2.16u rfmode=0
M$4 VDD C Y VDD sg13_lv_pmos L=0.13u W=1.12u AS=0.3808p AD=0.2128p PS=2.92u
+ PD=1.5u rfmode=0
M$5 Y B VDD VDD sg13_lv_pmos L=0.13u W=1.12u AS=0.2128p AD=0.2128p PS=1.5u
+ PD=1.5u rfmode=0
M$6 VDD A Y VDD sg13_lv_pmos L=0.13u W=1.12u AS=0.2128p AD=0.3808p PS=1.5u
+ PD=2.92u rfmode=0
.ENDS sg13g2_nand3_1

.SUBCKT sg13g2_nand2_1 VDD VSS Y A B
M$1 VSS B \$6 VSS sg13_lv_nmos L=0.13u W=0.74u AS=0.2516p AD=0.1406p PS=2.16u
+ PD=1.12u rfmode=0
M$2 \$6 A Y VSS sg13_lv_nmos L=0.13u W=0.74u AS=0.1406p AD=0.2516p PS=1.12u
+ PD=2.16u rfmode=0
M$3 VDD B Y VDD sg13_lv_pmos L=0.13u W=1.12u AS=0.3808p AD=0.2128p PS=2.92u
+ PD=1.5u rfmode=0
M$4 Y A VDD VDD sg13_lv_pmos L=0.13u W=1.12u AS=0.2128p AD=0.3808p PS=1.5u
+ PD=2.92u rfmode=0
.ENDS sg13g2_nand2_1

.SUBCKT sg13g2_nor2b_1 VSS VDD Y A B_N
M$1 VSS B_N \$5 VSS sg13_lv_nmos L=0.13u W=0.55u AS=0.17255p AD=0.187p PS=1.25u
+ PD=1.78u rfmode=0
M$2 VSS \$5 Y VSS sg13_lv_nmos L=0.13u W=0.74u AS=0.17255p AD=0.1406p PS=1.25u
+ PD=1.12u rfmode=0
M$3 Y A VSS VSS sg13_lv_nmos L=0.13u W=0.74u AS=0.1406p AD=0.2516p PS=1.12u
+ PD=2.16u rfmode=0
M$4 \$5 B_N VDD VDD sg13_lv_pmos L=0.13u W=0.84u AS=0.2856p AD=0.2618p PS=2.36u
+ PD=1.63u rfmode=0
M$5 VDD \$5 \$7 VDD sg13_lv_pmos L=0.13u W=1.12u AS=0.2618p AD=0.1176p PS=1.63u
+ PD=1.33u rfmode=0
M$6 \$7 A Y VDD sg13_lv_pmos L=0.13u W=1.12u AS=0.1176p AD=0.3808p PS=1.33u
+ PD=2.92u rfmode=0
.ENDS sg13g2_nor2b_1

.SUBCKT sg13g2_tiehi L_HI VDD VSS
M$1 VSS \$5 \$5 VSS sg13_lv_nmos L=0.13u W=0.3u AS=0.2043375p AD=0.111p
+ PS=1.585u PD=1.34u rfmode=0
M$2 VSS \$3 \$1 VSS sg13_lv_nmos L=0.13u W=0.795u AS=0.2043375p AD=0.274275p
+ PS=1.585u PD=2.28u rfmode=0
M$3 \$3 \$5 VDD VDD sg13_lv_pmos L=0.13u W=0.66u AS=0.2442p AD=0.4657125p
+ PS=2.06u PD=2.54u rfmode=0
M$4 VDD \$1 L_HI VDD sg13_lv_pmos L=0.13u W=1.155u AS=0.4657125p AD=0.3927p
+ PS=2.54u PD=2.99u rfmode=0
.ENDS sg13g2_tiehi

.SUBCKT sg13g2_and4_1 VSS VDD X D C B A
M$1 \$4 A \$11 VSS sg13_lv_nmos L=0.13u W=0.64u AS=0.2176p AD=0.1216p PS=1.96u
+ PD=1.02u rfmode=0
M$2 \$11 B \$10 VSS sg13_lv_nmos L=0.13u W=0.64u AS=0.1216p AD=0.1216p PS=1.02u
+ PD=1.02u rfmode=0
M$3 \$10 C \$9 VSS sg13_lv_nmos L=0.13u W=0.64u AS=0.1216p AD=0.1408p PS=1.02u
+ PD=1.08u rfmode=0
M$4 \$9 D VSS VSS sg13_lv_nmos L=0.13u W=0.64u AS=0.1408p AD=0.1447p PS=1.08u
+ PD=1.15u rfmode=0
M$5 VSS \$4 X VSS sg13_lv_nmos L=0.13u W=0.74u AS=0.1447p AD=0.3552p PS=1.15u
+ PD=2.44u rfmode=0
M$6 VDD A \$4 VDD sg13_lv_pmos L=0.13u W=0.84u AS=0.2856p AD=0.1596p PS=2.36u
+ PD=1.22u rfmode=0
M$7 \$4 B VDD VDD sg13_lv_pmos L=0.13u W=0.84u AS=0.1596p AD=0.1596p PS=1.22u
+ PD=1.22u rfmode=0
M$8 VDD C \$4 VDD sg13_lv_pmos L=0.13u W=0.84u AS=0.1596p AD=0.1848p PS=1.22u
+ PD=1.28u rfmode=0
M$9 VDD D \$4 VDD sg13_lv_pmos L=0.13u W=0.84u AS=0.2044p AD=0.1848p PS=1.53u
+ PD=1.28u rfmode=0
M$10 VDD \$4 X VDD sg13_lv_pmos L=0.13u W=1.12u AS=0.2044p AD=0.5376p PS=1.53u
+ PD=3.2u rfmode=0
.ENDS sg13g2_and4_1

.SUBCKT sg13g2_nor3_1 VDD VSS C Y B A
M$1 VSS A Y VSS sg13_lv_nmos L=0.13u W=0.77u AS=0.2618p AD=0.1694p PS=2.22u
+ PD=1.21u rfmode=0
M$2 Y B VSS VSS sg13_lv_nmos L=0.13u W=0.77u AS=0.1694p AD=0.1463p PS=1.21u
+ PD=1.15u rfmode=0
M$3 VSS C Y VSS sg13_lv_nmos L=0.13u W=0.77u AS=0.1463p AD=0.2618p PS=1.15u
+ PD=2.22u rfmode=0
M$4 VDD A \$8 VDD sg13_lv_pmos L=0.13u W=1.12u AS=0.3808p AD=0.2464p PS=2.92u
+ PD=1.56u rfmode=0
M$5 \$8 B \$7 VDD sg13_lv_pmos L=0.13u W=1.12u AS=0.2464p AD=0.2128p PS=1.56u
+ PD=1.5u rfmode=0
M$6 \$7 C Y VDD sg13_lv_pmos L=0.13u W=1.12u AS=0.2128p AD=0.3808p PS=1.5u
+ PD=2.92u rfmode=0
.ENDS sg13g2_nor3_1

.SUBCKT sg13g2_buf_8 VSS A X VDD
M$1 \$2 A VSS VSS sg13_lv_nmos L=0.13u W=2.22u AS=0.5365p AD=0.4218p PS=4.41u
+ PD=3.36u rfmode=0
M$4 VSS \$2 X VSS sg13_lv_nmos L=0.13u W=5.92u AS=1.1248p AD=1.2358p PS=8.96u
+ PD=10u rfmode=0
M$12 \$2 A VDD VDD sg13_lv_pmos L=0.13u W=3.36u AS=0.8064p AD=0.6384p PS=5.92u
+ PD=4.5u rfmode=0
M$15 VDD \$2 X VDD sg13_lv_pmos L=0.13u W=8.96u AS=1.7024p AD=1.876p PS=12u
+ PD=13.43u rfmode=0
.ENDS sg13g2_buf_8

.SUBCKT sg13g2_o21ai_1 VSS Y VDD B1 A2 A1
M$1 \$2 A1 VSS VSS sg13_lv_nmos L=0.15u W=0.74u AS=0.2516p AD=0.1406p PS=2.16u
+ PD=1.12u rfmode=0
M$2 VSS A2 \$2 VSS sg13_lv_nmos L=0.15u W=0.74u AS=0.1406p AD=0.1406p PS=1.12u
+ PD=1.12u rfmode=0
M$3 \$2 B1 Y VSS sg13_lv_nmos L=0.15u W=0.74u AS=0.1406p AD=0.2516p PS=1.12u
+ PD=2.16u rfmode=0
M$4 VDD A1 \$8 VDD sg13_lv_pmos L=0.15u W=1.12u AS=0.3808p AD=0.2128p PS=2.92u
+ PD=1.5u rfmode=0
M$5 \$8 A2 Y VDD sg13_lv_pmos L=0.15u W=1.12u AS=0.2128p AD=0.2128p PS=1.5u
+ PD=1.5u rfmode=0
M$6 Y B1 VDD VDD sg13_lv_pmos L=0.15u W=1.12u AS=0.2128p AD=0.3808p PS=1.5u
+ PD=2.92u rfmode=0
.ENDS sg13g2_o21ai_1

.SUBCKT sg13g2_nor2_1 VDD VSS B A Y
M$1 VSS A Y VSS sg13_lv_nmos L=0.13u W=0.74u AS=0.2516p AD=0.1406p PS=2.16u
+ PD=1.12u rfmode=0
M$2 Y B VSS VSS sg13_lv_nmos L=0.13u W=0.74u AS=0.1406p AD=0.2516p PS=1.12u
+ PD=2.16u rfmode=0
M$3 VDD A \$6 VDD sg13_lv_pmos L=0.13u W=1.12u AS=0.4032p AD=0.1176p PS=2.96u
+ PD=1.33u rfmode=0
M$4 \$6 B Y VDD sg13_lv_pmos L=0.13u W=1.12u AS=0.1176p AD=0.3808p PS=1.33u
+ PD=2.92u rfmode=0
.ENDS sg13g2_nor2_1

.SUBCKT sg13g2_nor4_1 VDD VSS B A C D Y
M$1 VSS A Y VSS sg13_lv_nmos L=0.13u W=0.74u AS=0.2516p AD=0.1406p PS=2.16u
+ PD=1.12u rfmode=0
M$2 Y B VSS VSS sg13_lv_nmos L=0.13u W=0.74u AS=0.1406p AD=0.1406p PS=1.12u
+ PD=1.12u rfmode=0
M$3 VSS C Y VSS sg13_lv_nmos L=0.13u W=0.74u AS=0.1406p AD=0.1406p PS=1.12u
+ PD=1.12u rfmode=0
M$4 Y D VSS VSS sg13_lv_nmos L=0.13u W=0.74u AS=0.1406p AD=0.237575p PS=1.12u
+ PD=2.16u rfmode=0
M$5 VDD A \$9 VDD sg13_lv_pmos L=0.13u W=1.12u AS=0.3808p AD=0.2128p PS=2.92u
+ PD=1.5u rfmode=0
M$6 \$9 B \$8 VDD sg13_lv_pmos L=0.13u W=1.12u AS=0.2128p AD=0.2128p PS=1.5u
+ PD=1.5u rfmode=0
M$7 \$8 C \$10 VDD sg13_lv_pmos L=0.13u W=1.12u AS=0.2128p AD=0.2128p PS=1.5u
+ PD=1.5u rfmode=0
M$8 \$10 D Y VDD sg13_lv_pmos L=0.13u W=1.12u AS=0.2128p AD=0.4368p PS=1.5u
+ PD=3.02u rfmode=0
.ENDS sg13g2_nor4_1

.SUBCKT sg13g2_or4_1 VDD VSS B D A C X
M$1 VSS D \$7 VSS sg13_lv_nmos L=0.13u W=0.55u AS=0.187p AD=0.1045p PS=1.78u
+ PD=0.93u rfmode=0
M$2 VSS C \$7 VSS sg13_lv_nmos L=0.13u W=0.55u AS=0.16755p AD=0.1045p PS=1.165u
+ PD=0.93u rfmode=0
M$3 VSS B \$7 VSS sg13_lv_nmos L=0.13u W=0.55u AS=0.16755p AD=0.1045p PS=1.165u
+ PD=0.93u rfmode=0
M$4 VSS A \$7 VSS sg13_lv_nmos L=0.13u W=0.55u AS=0.14135p AD=0.1045p PS=1.14u
+ PD=0.93u rfmode=0
M$5 VSS \$7 X VSS sg13_lv_nmos L=0.13u W=0.74u AS=0.14135p AD=0.2516p PS=1.14u
+ PD=2.16u rfmode=0
M$6 \$7 D \$11 VDD sg13_lv_pmos L=0.13u W=1u AS=0.34p AD=0.19p PS=2.68u
+ PD=1.38u rfmode=0
M$7 \$11 C \$10 VDD sg13_lv_pmos L=0.13u W=1u AS=0.19p AD=0.2925p PS=1.38u
+ PD=1.585u rfmode=0
M$8 \$10 B \$9 VDD sg13_lv_pmos L=0.13u W=1u AS=0.2925p AD=0.19p PS=1.585u
+ PD=1.38u rfmode=0
M$9 VDD A \$9 VDD sg13_lv_pmos L=0.13u W=1u AS=0.2144p AD=0.19p PS=1.52u
+ PD=1.38u rfmode=0
M$10 VDD \$7 X VDD sg13_lv_pmos L=0.13u W=1.12u AS=0.2144p AD=0.3808p PS=1.52u
+ PD=2.92u rfmode=0
.ENDS sg13g2_or4_1

.SUBCKT sg13g2_nand4_1 VDD A VSS Y B C D
M$1 VSS D \$10 VSS sg13_lv_nmos L=0.13u W=0.74u AS=0.2516p AD=0.1406p PS=2.16u
+ PD=1.12u rfmode=0
M$2 \$10 C \$9 VSS sg13_lv_nmos L=0.13u W=0.74u AS=0.1406p AD=0.1406p PS=1.12u
+ PD=1.12u rfmode=0
M$3 \$9 B \$8 VSS sg13_lv_nmos L=0.13u W=0.74u AS=0.1406p AD=0.1406p PS=1.12u
+ PD=1.12u rfmode=0
M$4 \$8 A Y VSS sg13_lv_nmos L=0.13u W=0.74u AS=0.1406p AD=0.2516p PS=1.12u
+ PD=2.16u rfmode=0
M$5 VDD D Y VDD sg13_lv_pmos L=0.13u W=1.12u AS=0.3808p AD=0.2128p PS=2.92u
+ PD=1.5u rfmode=0
M$6 Y C VDD VDD sg13_lv_pmos L=0.13u W=1.12u AS=0.2128p AD=0.2128p PS=1.5u
+ PD=1.5u rfmode=0
M$7 VDD B Y VDD sg13_lv_pmos L=0.13u W=1.12u AS=0.2128p AD=0.2128p PS=1.5u
+ PD=1.5u rfmode=0
M$8 Y A VDD VDD sg13_lv_pmos L=0.13u W=1.12u AS=0.2128p AD=0.3808p PS=1.5u
+ PD=2.92u rfmode=0
.ENDS sg13g2_nand4_1

.SUBCKT sg13g2_mux2_1 VSS X S A1 A0 VDD
M$1 VSS S \$2 VSS sg13_lv_nmos L=0.13u W=0.55u AS=0.18945p AD=0.187p PS=1.27u
+ PD=1.78u rfmode=0
M$2 VSS S \$8 VSS sg13_lv_nmos L=0.13u W=0.74u AS=0.18945p AD=0.13135p PS=1.27u
+ PD=1.095u rfmode=0
M$3 \$8 A1 \$3 VSS sg13_lv_nmos L=0.13u W=0.74u AS=0.13135p AD=0.1628p
+ PS=1.095u PD=1.18u rfmode=0
M$4 \$3 A0 \$9 VSS sg13_lv_nmos L=0.13u W=0.74u AS=0.1628p AD=0.3367p PS=1.18u
+ PD=1.65u rfmode=0
M$5 \$9 \$2 VSS VSS sg13_lv_nmos L=0.13u W=0.74u AS=0.3367p AD=0.148p PS=1.65u
+ PD=1.14u rfmode=0
M$6 VSS \$3 X VSS sg13_lv_nmos L=0.13u W=0.74u AS=0.148p AD=0.4033p PS=1.14u
+ PD=2.57u rfmode=0
M$7 \$2 S VDD VDD sg13_lv_pmos L=0.13u W=0.84u AS=0.2856p AD=0.253p PS=2.36u
+ PD=1.53u rfmode=0
M$8 VDD S \$10 VDD sg13_lv_pmos L=0.13u W=1u AS=0.253p AD=0.3325p PS=1.53u
+ PD=1.665u rfmode=0
M$9 \$10 A0 \$3 VDD sg13_lv_pmos L=0.13u W=1u AS=0.3325p AD=0.2225p PS=1.665u
+ PD=1.445u rfmode=0
M$10 \$3 A1 \$11 VDD sg13_lv_pmos L=0.13u W=1u AS=0.2225p AD=0.2975p PS=1.445u
+ PD=1.595u rfmode=0
M$11 \$11 \$2 VDD VDD sg13_lv_pmos L=0.13u W=1u AS=0.2975p AD=0.2198p PS=1.595u
+ PD=1.52u rfmode=0
M$12 VDD \$3 X VDD sg13_lv_pmos L=0.13u W=1.12u AS=0.2198p AD=0.6048p PS=1.52u
+ PD=3.32u rfmode=0
.ENDS sg13g2_mux2_1

.SUBCKT sg13g2_a221oi_1 VSS B1 VDD Y B2 C1 A1 A2
M$1 Y A1 \$11 VSS sg13_lv_nmos L=0.13u W=0.74u AS=0.2516p AD=0.1406p PS=2.16u
+ PD=1.12u rfmode=0
M$2 \$11 A2 VSS VSS sg13_lv_nmos L=0.13u W=0.74u AS=0.1406p AD=0.2516p PS=1.12u
+ PD=2.16u rfmode=0
M$3 Y C1 VSS VSS sg13_lv_nmos L=0.13u W=0.74u AS=0.2516p AD=0.1406p PS=2.16u
+ PD=1.12u rfmode=0
M$4 VSS B2 \$12 VSS sg13_lv_nmos L=0.13u W=0.74u AS=0.1406p AD=0.1406p PS=1.12u
+ PD=1.12u rfmode=0
M$5 \$12 B1 Y VSS sg13_lv_nmos L=0.13u W=0.74u AS=0.1406p AD=0.2516p PS=1.12u
+ PD=2.16u rfmode=0
M$6 VDD A1 \$9 VDD sg13_lv_pmos L=0.13u W=1.12u AS=0.3808p AD=0.2128p PS=2.92u
+ PD=1.5u rfmode=0
M$7 \$9 A2 VDD VDD sg13_lv_pmos L=0.13u W=1.12u AS=0.2128p AD=0.3808p PS=1.5u
+ PD=2.92u rfmode=0
M$8 Y C1 \$6 VDD sg13_lv_pmos L=0.13u W=1.12u AS=0.3808p AD=0.2128p PS=2.92u
+ PD=1.5u rfmode=0
M$9 \$6 B2 \$9 VDD sg13_lv_pmos L=0.13u W=1.12u AS=0.2128p AD=0.2128p PS=1.5u
+ PD=1.5u rfmode=0
M$10 \$9 B1 \$6 VDD sg13_lv_pmos L=0.13u W=1.12u AS=0.2128p AD=0.3808p PS=1.5u
+ PD=2.92u rfmode=0
.ENDS sg13g2_a221oi_1

.SUBCKT sg13g2_a21oi_1 VDD Y VSS A2 A1 B1
M$1 VSS B1 Y VSS sg13_lv_nmos L=0.13u W=0.74u AS=0.2516p AD=0.1406p PS=2.16u
+ PD=1.12u rfmode=0
M$2 Y A1 \$8 VSS sg13_lv_nmos L=0.13u W=0.74u AS=0.1406p AD=0.1406p PS=1.12u
+ PD=1.12u rfmode=0
M$3 \$8 A2 VSS VSS sg13_lv_nmos L=0.13u W=0.74u AS=0.1406p AD=0.2516p PS=1.12u
+ PD=2.16u rfmode=0
M$4 Y B1 \$4 VDD sg13_lv_pmos L=0.13u W=1.12u AS=0.3808p AD=0.2128p PS=2.92u
+ PD=1.5u rfmode=0
M$5 \$4 A1 VDD VDD sg13_lv_pmos L=0.13u W=1.12u AS=0.2128p AD=0.2128p PS=1.5u
+ PD=1.5u rfmode=0
M$6 VDD A2 \$4 VDD sg13_lv_pmos L=0.13u W=1.12u AS=0.2128p AD=0.3808p PS=1.5u
+ PD=2.92u rfmode=0
.ENDS sg13g2_a21oi_1

.SUBCKT sg13g2_xnor2_1 VDD VSS Y B A
M$1 VSS A \$8 VSS sg13_lv_nmos L=0.13u W=0.64u AS=0.2272p AD=0.0784p PS=1.99u
+ PD=0.885u rfmode=0
M$2 \$8 B \$7 VSS sg13_lv_nmos L=0.13u W=0.64u AS=0.0784p AD=0.2176p PS=0.885u
+ PD=1.96u rfmode=0
M$3 VSS A \$3 VSS sg13_lv_nmos L=0.13u W=0.74u AS=0.1898p AD=0.2516p PS=1.36u
+ PD=2.16u rfmode=0
M$4 VSS B \$3 VSS sg13_lv_nmos L=0.13u W=0.74u AS=0.1898p AD=0.1406p PS=1.36u
+ PD=1.12u rfmode=0
M$5 \$3 \$7 Y VSS sg13_lv_nmos L=0.13u W=0.74u AS=0.1406p AD=0.2516p PS=1.12u
+ PD=2.16u rfmode=0
M$6 VDD A \$7 VDD sg13_lv_pmos L=0.13u W=0.84u AS=0.4536p AD=0.1596p PS=2.76u
+ PD=1.22u rfmode=0
M$7 VDD B \$7 VDD sg13_lv_pmos L=0.13u W=0.84u AS=0.2891p AD=0.1596p PS=1.695u
+ PD=1.22u rfmode=0
M$8 VDD A \$9 VDD sg13_lv_pmos L=0.13u W=1.12u AS=0.2891p AD=0.1428p PS=1.695u
+ PD=1.375u rfmode=0
M$9 \$9 B Y VDD sg13_lv_pmos L=0.13u W=1.12u AS=0.1428p AD=0.2408p PS=1.375u
+ PD=1.55u rfmode=0
M$10 Y \$7 VDD VDD sg13_lv_pmos L=0.13u W=1.12u AS=0.2408p AD=0.3808p PS=1.55u
+ PD=2.92u rfmode=0
.ENDS sg13g2_xnor2_1

.SUBCKT sg13g2_inv_1 VDD VSS A Y
M$1 VSS A Y VSS sg13_lv_nmos L=0.13u W=0.74u AS=0.2516p AD=0.2516p PS=2.16u
+ PD=2.16u rfmode=0
M$2 VDD A Y VDD sg13_lv_pmos L=0.13u W=1.12u AS=0.3808p AD=0.3808p PS=2.92u
+ PD=2.92u rfmode=0
.ENDS sg13g2_inv_1

.SUBCKT sg13g2_and2_1 VDD VSS X A B
M$1 \$4 A \$7 VSS sg13_lv_nmos L=0.13u W=0.64u AS=0.2176p AD=0.1216p PS=1.96u
+ PD=1.02u rfmode=0
M$2 VSS B \$7 VSS sg13_lv_nmos L=0.13u W=0.64u AS=0.1331p AD=0.1216p PS=1.12u
+ PD=1.02u rfmode=0
M$3 VSS \$4 X VSS sg13_lv_nmos L=0.13u W=0.74u AS=0.1331p AD=0.2516p PS=1.12u
+ PD=2.16u rfmode=0
M$4 VDD A \$4 VDD sg13_lv_pmos L=0.13u W=0.84u AS=0.2856p AD=0.1596p PS=2.36u
+ PD=1.22u rfmode=0
M$5 VDD B \$4 VDD sg13_lv_pmos L=0.13u W=0.84u AS=0.1918p AD=0.1596p PS=1.5u
+ PD=1.22u rfmode=0
M$6 VDD \$4 X VDD sg13_lv_pmos L=0.13u W=1.12u AS=0.1918p AD=0.3808p PS=1.5u
+ PD=2.92u rfmode=0
.ENDS sg13g2_and2_1

.SUBCKT sg13g2_buf_1 VSS X VDD A
M$1 VSS A \$1 VSS sg13_lv_nmos L=0.13u W=0.55u AS=0.14875p AD=0.187p PS=1.16u
+ PD=1.78u rfmode=0
M$2 VSS \$1 X VSS sg13_lv_nmos L=0.13u W=0.74u AS=0.14875p AD=0.2886p PS=1.16u
+ PD=2.26u rfmode=0
M$3 VDD A \$1 VDD sg13_lv_pmos L=0.13u W=0.84u AS=0.2114p AD=0.2856p PS=1.54u
+ PD=2.36u rfmode=0
M$4 VDD \$1 X VDD sg13_lv_pmos L=0.13u W=1.12u AS=0.2114p AD=0.42p PS=1.54u
+ PD=2.99u rfmode=0
.ENDS sg13g2_buf_1

.SUBCKT sg13g2_nand2b_1 VDD VSS B A_N Y
M$1 VSS A_N \$6 VSS sg13_lv_nmos L=0.13u W=0.55u AS=0.14505p AD=0.187p PS=1.15u
+ PD=1.78u rfmode=0
M$2 VSS B \$7 VSS sg13_lv_nmos L=0.13u W=0.74u AS=0.14505p AD=0.1406p PS=1.15u
+ PD=1.12u rfmode=0
M$3 \$7 \$6 Y VSS sg13_lv_nmos L=0.13u W=0.74u AS=0.1406p AD=0.333p PS=1.12u
+ PD=2.38u rfmode=0
M$4 \$6 A_N VDD VDD sg13_lv_pmos L=0.13u W=0.84u AS=0.2856p AD=0.2198p PS=2.36u
+ PD=1.53u rfmode=0
M$5 VDD B Y VDD sg13_lv_pmos L=0.13u W=1.12u AS=0.2198p AD=0.2128p PS=1.53u
+ PD=1.5u rfmode=0
M$6 Y \$6 VDD VDD sg13_lv_pmos L=0.13u W=1.12u AS=0.2128p AD=0.3808p PS=1.5u
+ PD=2.92u rfmode=0
.ENDS sg13g2_nand2b_1

.SUBCKT sg13g2_dlygate4sd3_1 VDD VSS X A
M$1 VSS \$5 \$4 VSS sg13_lv_nmos L=0.5u W=0.42u AS=0.1426p AD=0.1428p PS=1.16u
+ PD=1.52u rfmode=0
M$2 VSS \$4 X VSS sg13_lv_nmos L=0.13u W=0.74u AS=0.1426p AD=0.2516p PS=1.16u
+ PD=2.16u rfmode=0
M$3 \$6 A VSS VSS sg13_lv_nmos L=0.13u W=0.42u AS=0.1428p AD=0.0798p PS=1.52u
+ PD=0.8u rfmode=0
M$4 VSS \$6 \$5 VSS sg13_lv_nmos L=0.5u W=0.42u AS=0.0798p AD=0.1428p PS=0.8u
+ PD=1.52u rfmode=0
M$5 \$4 \$5 VDD VDD sg13_lv_pmos L=0.5u W=1u AS=0.34p AD=0.2254p PS=2.68u
+ PD=1.53u rfmode=0
M$6 VDD \$4 X VDD sg13_lv_pmos L=0.13u W=1.12u AS=0.2254p AD=0.4256p PS=1.53u
+ PD=3u rfmode=0
M$7 VDD A \$6 VDD sg13_lv_pmos L=0.13u W=0.42u AS=0.1523p AD=0.1428p PS=1.38u
+ PD=1.52u rfmode=0
M$8 VDD \$6 \$5 VDD sg13_lv_pmos L=0.5u W=1u AS=0.1523p AD=0.34p PS=1.38u
+ PD=2.68u rfmode=0
.ENDS sg13g2_dlygate4sd3_1

.SUBCKT sg13g2_dfrbpq_1 VSS RESET_B Q D CLK VDD
M$1 VSS \$4 \$19 VSS sg13_lv_nmos L=0.13u W=0.74u AS=0.317325p AD=0.2516p
+ PS=1.805u PD=2.16u rfmode=0
M$2 VSS CLK \$4 VSS sg13_lv_nmos L=0.13u W=0.74u AS=0.317325p AD=0.2516p
+ PS=1.805u PD=2.16u rfmode=0
M$3 \$14 \$4 \$7 VSS sg13_lv_nmos L=0.13u W=0.42u AS=0.12665p AD=0.1428p
+ PS=1.145u PD=1.52u rfmode=0
M$4 \$3 \$19 \$14 VSS sg13_lv_nmos L=0.13u W=0.74u AS=0.3473p AD=0.12665p
+ PS=2.71u PD=1.145u rfmode=0
M$5 \$7 \$8 VSS VSS sg13_lv_nmos L=0.13u W=0.42u AS=0.1428p AD=0.0798p PS=1.52u
+ PD=0.8u rfmode=0
M$6 VSS RESET_B \$17 VSS sg13_lv_nmos L=0.13u W=0.42u AS=0.0798p AD=0.0378p
+ PS=0.8u PD=0.6u rfmode=0
M$7 \$17 \$14 \$8 VSS sg13_lv_nmos L=0.13u W=0.42u AS=0.0378p AD=0.1428p
+ PS=0.6u PD=1.52u rfmode=0
M$8 \$9 \$14 VSS VSS sg13_lv_nmos L=0.13u W=0.74u AS=0.2516p AD=0.1406p
+ PS=2.16u PD=1.12u rfmode=0
M$9 VSS \$9 Q VSS sg13_lv_nmos L=0.13u W=0.74u AS=0.1406p AD=0.2516p PS=1.12u
+ PD=2.16u rfmode=0
M$10 \$5 D \$15 VSS sg13_lv_nmos L=0.13u W=0.42u AS=0.1428p AD=0.0609p PS=1.52u
+ PD=0.71u rfmode=0
M$11 \$15 RESET_B VSS VSS sg13_lv_nmos L=0.13u W=0.42u AS=0.0609p AD=0.1626p
+ PS=0.71u PD=1.415u rfmode=0
M$12 VSS \$12 \$3 VSS sg13_lv_nmos L=0.13u W=0.74u AS=0.1626p AD=0.2516p
+ PS=1.415u PD=2.16u rfmode=0
M$13 \$5 \$4 \$12 VSS sg13_lv_nmos L=0.13u W=0.42u AS=0.1296p AD=0.0798p
+ PS=1.52u PD=0.8u rfmode=0
M$14 \$12 \$19 \$6 VSS sg13_lv_nmos L=0.13u W=0.42u AS=0.0798p AD=0.2373p
+ PS=0.8u PD=1.97u rfmode=0
M$15 VSS RESET_B \$16 VSS sg13_lv_nmos L=0.13u W=0.42u AS=0.1701p AD=0.0378p
+ PS=1.65u PD=0.6u rfmode=0
M$16 \$16 \$3 \$6 VSS sg13_lv_nmos L=0.13u W=0.42u AS=0.0378p AD=0.1428p
+ PS=0.6u PD=1.52u rfmode=0
M$17 \$14 \$19 \$21 VDD sg13_lv_pmos L=0.13u W=0.42u AS=0.2048p AD=0.09345p
+ PS=1.63u PD=0.865u rfmode=0
M$18 \$21 \$8 VDD VDD sg13_lv_pmos L=0.13u W=0.42u AS=0.09345p AD=0.204p
+ PS=0.865u PD=1.835u rfmode=0
M$19 VDD RESET_B \$8 VDD sg13_lv_pmos L=0.13u W=0.42u AS=0.204p AD=0.0798p
+ PS=1.835u PD=0.8u rfmode=0
M$20 \$8 \$14 VDD VDD sg13_lv_pmos L=0.13u W=0.42u AS=0.0798p AD=0.4659p
+ PS=0.8u PD=3.65u rfmode=0
M$21 \$3 \$4 \$14 VDD sg13_lv_pmos L=0.13u W=1u AS=0.34p AD=0.2048p PS=2.68u
+ PD=1.63u rfmode=0
M$22 \$9 \$14 VDD VDD sg13_lv_pmos L=0.13u W=1.12u AS=0.3864p AD=0.2128p
+ PS=2.93u PD=1.5u rfmode=0
M$23 VDD \$9 Q VDD sg13_lv_pmos L=0.13u W=1.12u AS=0.2128p AD=0.3808p PS=1.5u
+ PD=2.92u rfmode=0
M$24 VDD D \$5 VDD sg13_lv_pmos L=0.13u W=0.42u AS=0.1428p AD=0.0798p PS=1.52u
+ PD=0.8u rfmode=0
M$25 VDD RESET_B \$5 VDD sg13_lv_pmos L=0.13u W=0.42u AS=0.3623875p AD=0.0798p
+ PS=2.605u PD=0.8u rfmode=0
M$26 VDD \$12 \$3 VDD sg13_lv_pmos L=0.13u W=1u AS=0.3623875p AD=0.34p
+ PS=2.605u PD=2.68u rfmode=0
M$27 \$19 \$4 VDD VDD sg13_lv_pmos L=0.13u W=1.12u AS=0.3864p AD=0.41165p
+ PS=2.93u PD=2.12u rfmode=0
M$28 VDD CLK \$4 VDD sg13_lv_pmos L=0.13u W=1.12u AS=0.41165p AD=0.4088p
+ PS=2.12u PD=2.97u rfmode=0
M$29 \$12 RESET_B VDD VDD sg13_lv_pmos L=0.13u W=0.42u AS=0.147p AD=0.1563p
+ PS=1.54u PD=1.22u rfmode=0
M$30 VDD \$3 \$20 VDD sg13_lv_pmos L=0.13u W=0.42u AS=0.1563p AD=0.063p
+ PS=1.22u PD=0.72u rfmode=0
M$31 \$20 \$4 \$12 VDD sg13_lv_pmos L=0.13u W=0.42u AS=0.063p AD=0.0798p
+ PS=0.72u PD=0.8u rfmode=0
M$32 \$12 \$19 \$5 VDD sg13_lv_pmos L=0.13u W=0.42u AS=0.0798p AD=0.1428p
+ PS=0.8u PD=1.52u rfmode=0
.ENDS sg13g2_dfrbpq_1
